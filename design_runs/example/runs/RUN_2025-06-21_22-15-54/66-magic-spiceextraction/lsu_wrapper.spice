* NGSPICE file created from lsu_wrapper.ext - technology: sky130A

* Black-box entry subcircuit for sky130_fd_sc_hd__fill_1 abstract view
.subckt sky130_fd_sc_hd__fill_1 VGND VNB VPB VPWR
.ends

* Black-box entry subcircuit for sky130_fd_sc_hd__decap_6 abstract view
.subckt sky130_fd_sc_hd__decap_6 VGND VNB VPB VPWR
.ends

* Black-box entry subcircuit for sky130_fd_sc_hd__decap_3 abstract view
.subckt sky130_fd_sc_hd__decap_3 VGND VNB VPB VPWR
.ends

* Black-box entry subcircuit for sky130_fd_sc_hd__mux2_1 abstract view
.subckt sky130_fd_sc_hd__mux2_1 A0 A1 S VGND VNB VPB VPWR X
.ends

* Black-box entry subcircuit for sky130_fd_sc_hd__and3_1 abstract view
.subckt sky130_fd_sc_hd__and3_1 A B C VGND VNB VPB VPWR X
.ends

* Black-box entry subcircuit for sky130_fd_sc_hd__mux4_1 abstract view
.subckt sky130_fd_sc_hd__mux4_1 A0 A1 A2 A3 S0 S1 VGND VNB VPB VPWR X
.ends

* Black-box entry subcircuit for sky130_fd_sc_hd__tapvpwrvgnd_1 abstract view
.subckt sky130_fd_sc_hd__tapvpwrvgnd_1 VGND VPWR
.ends

* Black-box entry subcircuit for sky130_fd_sc_hd__dfxtp_1 abstract view
.subckt sky130_fd_sc_hd__dfxtp_1 CLK D VGND VNB VPB VPWR Q
.ends

* Black-box entry subcircuit for sky130_fd_sc_hd__dlygate4sd3_1 abstract view
.subckt sky130_fd_sc_hd__dlygate4sd3_1 A VGND VNB VPB VPWR X
.ends

* Black-box entry subcircuit for sky130_ef_sc_hd__decap_12 abstract view
.subckt sky130_ef_sc_hd__decap_12 VPWR VGND VPB VNB
.ends

* Black-box entry subcircuit for sky130_fd_sc_hd__fill_2 abstract view
.subckt sky130_fd_sc_hd__fill_2 VGND VNB VPB VPWR
.ends

* Black-box entry subcircuit for sky130_fd_sc_hd__decap_4 abstract view
.subckt sky130_fd_sc_hd__decap_4 VGND VNB VPB VPWR
.ends

* Black-box entry subcircuit for sky130_fd_sc_hd__dlygate4sd1_1 abstract view
.subckt sky130_fd_sc_hd__dlygate4sd1_1 A VGND VNB VPB VPWR X
.ends

* Black-box entry subcircuit for sky130_fd_sc_hd__decap_8 abstract view
.subckt sky130_fd_sc_hd__decap_8 VGND VNB VPB VPWR
.ends

* Black-box entry subcircuit for sky130_fd_sc_hd__dfrtp_1 abstract view
.subckt sky130_fd_sc_hd__dfrtp_1 CLK D RESET_B VGND VNB VPB VPWR Q
.ends

* Black-box entry subcircuit for sky130_fd_sc_hd__a21o_1 abstract view
.subckt sky130_fd_sc_hd__a21o_1 A1 A2 B1 VGND VNB VPB VPWR X
.ends

* Black-box entry subcircuit for sky130_fd_sc_hd__and3b_2 abstract view
.subckt sky130_fd_sc_hd__and3b_2 A_N B C VGND VNB VPB VPWR X
.ends

* Black-box entry subcircuit for sky130_fd_sc_hd__o22a_1 abstract view
.subckt sky130_fd_sc_hd__o22a_1 A1 A2 B1 B2 VGND VNB VPB VPWR X
.ends

* Black-box entry subcircuit for sky130_fd_sc_hd__o21ba_1 abstract view
.subckt sky130_fd_sc_hd__o21ba_1 A1 A2 B1_N VGND VNB VPB VPWR X
.ends

* Black-box entry subcircuit for sky130_fd_sc_hd__or2_1 abstract view
.subckt sky130_fd_sc_hd__or2_1 A B VGND VNB VPB VPWR X
.ends

* Black-box entry subcircuit for sky130_fd_sc_hd__a21bo_1 abstract view
.subckt sky130_fd_sc_hd__a21bo_1 A1 A2 B1_N VGND VNB VPB VPWR X
.ends

* Black-box entry subcircuit for sky130_fd_sc_hd__or2_2 abstract view
.subckt sky130_fd_sc_hd__or2_2 A B VGND VNB VPB VPWR X
.ends

* Black-box entry subcircuit for sky130_fd_sc_hd__inv_2 abstract view
.subckt sky130_fd_sc_hd__inv_2 A VGND VNB VPB VPWR Y
.ends

* Black-box entry subcircuit for sky130_fd_sc_hd__a22o_1 abstract view
.subckt sky130_fd_sc_hd__a22o_1 A1 A2 B1 B2 VGND VNB VPB VPWR X
.ends

* Black-box entry subcircuit for sky130_fd_sc_hd__o21a_1 abstract view
.subckt sky130_fd_sc_hd__o21a_1 A1 A2 B1 VGND VNB VPB VPWR X
.ends

* Black-box entry subcircuit for sky130_fd_sc_hd__a31o_1 abstract view
.subckt sky130_fd_sc_hd__a31o_1 A1 A2 A3 B1 VGND VNB VPB VPWR X
.ends

* Black-box entry subcircuit for sky130_fd_sc_hd__nand2b_1 abstract view
.subckt sky130_fd_sc_hd__nand2b_1 A_N B VGND VNB VPB VPWR Y
.ends

* Black-box entry subcircuit for sky130_fd_sc_hd__and4_1 abstract view
.subckt sky130_fd_sc_hd__and4_1 A B C D VGND VNB VPB VPWR X
.ends

* Black-box entry subcircuit for sky130_fd_sc_hd__o2111a_1 abstract view
.subckt sky130_fd_sc_hd__o2111a_1 A1 A2 B1 C1 D1 VGND VNB VPB VPWR X
.ends

* Black-box entry subcircuit for sky130_fd_sc_hd__a21boi_2 abstract view
.subckt sky130_fd_sc_hd__a21boi_2 A1 A2 B1_N VGND VNB VPB VPWR Y
.ends

* Black-box entry subcircuit for sky130_fd_sc_hd__and2_1 abstract view
.subckt sky130_fd_sc_hd__and2_1 A B VGND VNB VPB VPWR X
.ends

* Black-box entry subcircuit for sky130_fd_sc_hd__diode_2 abstract view
.subckt sky130_fd_sc_hd__diode_2 DIODE VGND VNB VPB VPWR
.ends

* Black-box entry subcircuit for sky130_fd_sc_hd__and3_2 abstract view
.subckt sky130_fd_sc_hd__and3_2 A B C VGND VNB VPB VPWR X
.ends

* Black-box entry subcircuit for sky130_fd_sc_hd__xnor2_2 abstract view
.subckt sky130_fd_sc_hd__xnor2_2 A B VGND VNB VPB VPWR Y
.ends

* Black-box entry subcircuit for sky130_fd_sc_hd__clkbuf_2 abstract view
.subckt sky130_fd_sc_hd__clkbuf_2 A VGND VNB VPB VPWR X
.ends

* Black-box entry subcircuit for sky130_fd_sc_hd__clkbuf_16 abstract view
.subckt sky130_fd_sc_hd__clkbuf_16 A VGND VNB VPB VPWR X
.ends

* Black-box entry subcircuit for sky130_fd_sc_hd__and3b_1 abstract view
.subckt sky130_fd_sc_hd__and3b_1 A_N B C VGND VNB VPB VPWR X
.ends

* Black-box entry subcircuit for sky130_fd_sc_hd__conb_1 abstract view
.subckt sky130_fd_sc_hd__conb_1 VGND VNB VPB VPWR HI LO
.ends

* Black-box entry subcircuit for sky130_fd_sc_hd__nand2_1 abstract view
.subckt sky130_fd_sc_hd__nand2_1 A B VGND VNB VPB VPWR Y
.ends

* Black-box entry subcircuit for sky130_fd_sc_hd__xor2_2 abstract view
.subckt sky130_fd_sc_hd__xor2_2 A B VGND VNB VPB VPWR X
.ends

* Black-box entry subcircuit for sky130_fd_sc_hd__nand3_2 abstract view
.subckt sky130_fd_sc_hd__nand3_2 A B C VGND VNB VPB VPWR Y
.ends

* Black-box entry subcircuit for sky130_fd_sc_hd__mux2_4 abstract view
.subckt sky130_fd_sc_hd__mux2_4 A0 A1 S VGND VNB VPB VPWR X
.ends

* Black-box entry subcircuit for sky130_fd_sc_hd__clkbuf_8 abstract view
.subckt sky130_fd_sc_hd__clkbuf_8 A VGND VNB VPB VPWR X
.ends

* Black-box entry subcircuit for sky130_fd_sc_hd__nor2_1 abstract view
.subckt sky130_fd_sc_hd__nor2_1 A B VGND VNB VPB VPWR Y
.ends

* Black-box entry subcircuit for sky130_fd_sc_hd__o21ai_1 abstract view
.subckt sky130_fd_sc_hd__o21ai_1 A1 A2 B1 VGND VNB VPB VPWR Y
.ends

* Black-box entry subcircuit for sky130_fd_sc_hd__o221a_1 abstract view
.subckt sky130_fd_sc_hd__o221a_1 A1 A2 B1 B2 C1 VGND VNB VPB VPWR X
.ends

* Black-box entry subcircuit for sky130_fd_sc_hd__or4b_1 abstract view
.subckt sky130_fd_sc_hd__or4b_1 A B C D_N VGND VNB VPB VPWR X
.ends

* Black-box entry subcircuit for sky130_fd_sc_hd__or4b_4 abstract view
.subckt sky130_fd_sc_hd__or4b_4 A B C D_N VGND VNB VPB VPWR X
.ends

* Black-box entry subcircuit for sky130_fd_sc_hd__or2_4 abstract view
.subckt sky130_fd_sc_hd__or2_4 A B VGND VNB VPB VPWR X
.ends

* Black-box entry subcircuit for sky130_fd_sc_hd__xor2_1 abstract view
.subckt sky130_fd_sc_hd__xor2_1 A B VGND VNB VPB VPWR X
.ends

* Black-box entry subcircuit for sky130_fd_sc_hd__or3_4 abstract view
.subckt sky130_fd_sc_hd__or3_4 A B C VGND VNB VPB VPWR X
.ends

* Black-box entry subcircuit for sky130_fd_sc_hd__nand2_2 abstract view
.subckt sky130_fd_sc_hd__nand2_2 A B VGND VNB VPB VPWR Y
.ends

* Black-box entry subcircuit for sky130_fd_sc_hd__a22oi_1 abstract view
.subckt sky130_fd_sc_hd__a22oi_1 A1 A2 B1 B2 VGND VNB VPB VPWR Y
.ends

* Black-box entry subcircuit for sky130_fd_sc_hd__xnor2_1 abstract view
.subckt sky130_fd_sc_hd__xnor2_1 A B VGND VNB VPB VPWR Y
.ends

* Black-box entry subcircuit for sky130_fd_sc_hd__a211o_1 abstract view
.subckt sky130_fd_sc_hd__a211o_1 A1 A2 B1 C1 VGND VNB VPB VPWR X
.ends

* Black-box entry subcircuit for sky130_fd_sc_hd__a21oi_1 abstract view
.subckt sky130_fd_sc_hd__a21oi_1 A1 A2 B1 VGND VNB VPB VPWR Y
.ends

* Black-box entry subcircuit for sky130_fd_sc_hd__clkinvlp_4 abstract view
.subckt sky130_fd_sc_hd__clkinvlp_4 A VGND VNB VPB VPWR Y
.ends

* Black-box entry subcircuit for sky130_fd_sc_hd__clkbuf_4 abstract view
.subckt sky130_fd_sc_hd__clkbuf_4 A VGND VNB VPB VPWR X
.ends

* Black-box entry subcircuit for sky130_fd_sc_hd__buf_2 abstract view
.subckt sky130_fd_sc_hd__buf_2 A VGND VNB VPB VPWR X
.ends

* Black-box entry subcircuit for sky130_fd_sc_hd__or3b_1 abstract view
.subckt sky130_fd_sc_hd__or3b_1 A B C_N VGND VNB VPB VPWR X
.ends

* Black-box entry subcircuit for sky130_fd_sc_hd__clkbuf_1 abstract view
.subckt sky130_fd_sc_hd__clkbuf_1 A VGND VNB VPB VPWR X
.ends

* Black-box entry subcircuit for sky130_fd_sc_hd__o31a_2 abstract view
.subckt sky130_fd_sc_hd__o31a_2 A1 A2 A3 B1 VGND VNB VPB VPWR X
.ends

* Black-box entry subcircuit for sky130_fd_sc_hd__or3_1 abstract view
.subckt sky130_fd_sc_hd__or3_1 A B C VGND VNB VPB VPWR X
.ends

* Black-box entry subcircuit for sky130_fd_sc_hd__inv_6 abstract view
.subckt sky130_fd_sc_hd__inv_6 A VGND VNB VPB VPWR Y
.ends

* Black-box entry subcircuit for sky130_fd_sc_hd__buf_1 abstract view
.subckt sky130_fd_sc_hd__buf_1 A VGND VNB VPB VPWR X
.ends

* Black-box entry subcircuit for sky130_fd_sc_hd__dfrtp_2 abstract view
.subckt sky130_fd_sc_hd__dfrtp_2 CLK D RESET_B VGND VNB VPB VPWR Q
.ends

* Black-box entry subcircuit for sky130_fd_sc_hd__a2111o_1 abstract view
.subckt sky130_fd_sc_hd__a2111o_1 A1 A2 B1 C1 D1 VGND VNB VPB VPWR X
.ends

* Black-box entry subcircuit for sky130_fd_sc_hd__buf_4 abstract view
.subckt sky130_fd_sc_hd__buf_4 A VGND VNB VPB VPWR X
.ends

* Black-box entry subcircuit for sky130_fd_sc_hd__clkinv_2 abstract view
.subckt sky130_fd_sc_hd__clkinv_2 A VGND VNB VPB VPWR Y
.ends

* Black-box entry subcircuit for sky130_fd_sc_hd__clkinv_8 abstract view
.subckt sky130_fd_sc_hd__clkinv_8 A VGND VNB VPB VPWR Y
.ends

* Black-box entry subcircuit for sky130_fd_sc_hd__a2bb2o_4 abstract view
.subckt sky130_fd_sc_hd__a2bb2o_4 A1_N A2_N B1 B2 VGND VNB VPB VPWR X
.ends

* Black-box entry subcircuit for sky130_fd_sc_hd__o2bb2a_1 abstract view
.subckt sky130_fd_sc_hd__o2bb2a_1 A1_N A2_N B1 B2 VGND VNB VPB VPWR X
.ends

* Black-box entry subcircuit for sky130_fd_sc_hd__and2b_1 abstract view
.subckt sky130_fd_sc_hd__and2b_1 A_N B VGND VNB VPB VPWR X
.ends

* Black-box entry subcircuit for sky130_fd_sc_hd__inv_8 abstract view
.subckt sky130_fd_sc_hd__inv_8 A VGND VNB VPB VPWR Y
.ends

* Black-box entry subcircuit for sky130_fd_sc_hd__bufinv_16 abstract view
.subckt sky130_fd_sc_hd__bufinv_16 A VGND VNB VPB VPWR Y
.ends

* Black-box entry subcircuit for sky130_fd_sc_hd__dlymetal6s2s_1 abstract view
.subckt sky130_fd_sc_hd__dlymetal6s2s_1 A VGND VNB VPB VPWR X
.ends

* Black-box entry subcircuit for sky130_fd_sc_hd__o21a_4 abstract view
.subckt sky130_fd_sc_hd__o21a_4 A1 A2 B1 VGND VNB VPB VPWR X
.ends

* Black-box entry subcircuit for sky130_fd_sc_hd__o32a_1 abstract view
.subckt sky130_fd_sc_hd__o32a_1 A1 A2 A3 B1 B2 VGND VNB VPB VPWR X
.ends

* Black-box entry subcircuit for sky130_fd_sc_hd__o211a_1 abstract view
.subckt sky130_fd_sc_hd__o211a_1 A1 A2 B1 C1 VGND VNB VPB VPWR X
.ends

* Black-box entry subcircuit for sky130_fd_sc_hd__o21ai_2 abstract view
.subckt sky130_fd_sc_hd__o21ai_2 A1 A2 B1 VGND VNB VPB VPWR Y
.ends

* Black-box entry subcircuit for sky130_fd_sc_hd__inv_12 abstract view
.subckt sky130_fd_sc_hd__inv_12 A VGND VNB VPB VPWR Y
.ends

* Black-box entry subcircuit for sky130_fd_sc_hd__a2bb2o_1 abstract view
.subckt sky130_fd_sc_hd__a2bb2o_1 A1_N A2_N B1 B2 VGND VNB VPB VPWR X
.ends

* Black-box entry subcircuit for sky130_fd_sc_hd__o2111ai_1 abstract view
.subckt sky130_fd_sc_hd__o2111ai_1 A1 A2 B1 C1 D1 VGND VNB VPB VPWR Y
.ends

* Black-box entry subcircuit for sky130_fd_sc_hd__dfrtp_4 abstract view
.subckt sky130_fd_sc_hd__dfrtp_4 CLK D RESET_B VGND VNB VPB VPWR Q
.ends

* Black-box entry subcircuit for sky130_fd_sc_hd__o22ai_2 abstract view
.subckt sky130_fd_sc_hd__o22ai_2 A1 A2 B1 B2 VGND VNB VPB VPWR Y
.ends

* Black-box entry subcircuit for sky130_fd_sc_hd__a221o_1 abstract view
.subckt sky130_fd_sc_hd__a221o_1 A1 A2 B1 B2 C1 VGND VNB VPB VPWR X
.ends

* Black-box entry subcircuit for sky130_fd_sc_hd__a21boi_1 abstract view
.subckt sky130_fd_sc_hd__a21boi_1 A1 A2 B1_N VGND VNB VPB VPWR Y
.ends

* Black-box entry subcircuit for sky130_fd_sc_hd__o2bb2a_4 abstract view
.subckt sky130_fd_sc_hd__o2bb2a_4 A1_N A2_N B1 B2 VGND VNB VPB VPWR X
.ends

* Black-box entry subcircuit for sky130_fd_sc_hd__o31ai_1 abstract view
.subckt sky130_fd_sc_hd__o31ai_1 A1 A2 A3 B1 VGND VNB VPB VPWR Y
.ends

* Black-box entry subcircuit for sky130_fd_sc_hd__clkinv_4 abstract view
.subckt sky130_fd_sc_hd__clkinv_4 A VGND VNB VPB VPWR Y
.ends

* Black-box entry subcircuit for sky130_fd_sc_hd__nor2_4 abstract view
.subckt sky130_fd_sc_hd__nor2_4 A B VGND VNB VPB VPWR Y
.ends

* Black-box entry subcircuit for sky130_fd_sc_hd__o31a_1 abstract view
.subckt sky130_fd_sc_hd__o31a_1 A1 A2 A3 B1 VGND VNB VPB VPWR X
.ends

* Black-box entry subcircuit for sky130_fd_sc_hd__and4b_1 abstract view
.subckt sky130_fd_sc_hd__and4b_1 A_N B C D VGND VNB VPB VPWR X
.ends

* Black-box entry subcircuit for sky130_fd_sc_hd__or4_4 abstract view
.subckt sky130_fd_sc_hd__or4_4 A B C D VGND VNB VPB VPWR X
.ends

* Black-box entry subcircuit for sky130_fd_sc_hd__inv_16 abstract view
.subckt sky130_fd_sc_hd__inv_16 A VGND VNB VPB VPWR Y
.ends

* Black-box entry subcircuit for sky130_fd_sc_hd__and2_2 abstract view
.subckt sky130_fd_sc_hd__and2_2 A B VGND VNB VPB VPWR X
.ends

* Black-box entry subcircuit for sky130_fd_sc_hd__a221oi_1 abstract view
.subckt sky130_fd_sc_hd__a221oi_1 A1 A2 B1 B2 C1 VGND VNB VPB VPWR Y
.ends

* Black-box entry subcircuit for sky130_fd_sc_hd__xor2_4 abstract view
.subckt sky130_fd_sc_hd__xor2_4 A B VGND VNB VPB VPWR X
.ends

* Black-box entry subcircuit for sky130_fd_sc_hd__and4bb_2 abstract view
.subckt sky130_fd_sc_hd__and4bb_2 A_N B_N C D VGND VNB VPB VPWR X
.ends

* Black-box entry subcircuit for sky130_fd_sc_hd__o22ai_1 abstract view
.subckt sky130_fd_sc_hd__o22ai_1 A1 A2 B1 B2 VGND VNB VPB VPWR Y
.ends

* Black-box entry subcircuit for sky130_fd_sc_hd__o211ai_1 abstract view
.subckt sky130_fd_sc_hd__o211ai_1 A1 A2 B1 C1 VGND VNB VPB VPWR Y
.ends

* Black-box entry subcircuit for sky130_fd_sc_hd__a2111oi_4 abstract view
.subckt sky130_fd_sc_hd__a2111oi_4 A1 A2 B1 C1 D1 VGND VNB VPB VPWR Y
.ends

* Black-box entry subcircuit for sky130_fd_sc_hd__nor4_1 abstract view
.subckt sky130_fd_sc_hd__nor4_1 A B C D VGND VNB VPB VPWR Y
.ends

* Black-box entry subcircuit for sky130_fd_sc_hd__or3b_4 abstract view
.subckt sky130_fd_sc_hd__or3b_4 A B C_N VGND VNB VPB VPWR X
.ends

* Black-box entry subcircuit for sky130_fd_sc_hd__buf_6 abstract view
.subckt sky130_fd_sc_hd__buf_6 A VGND VNB VPB VPWR X
.ends

* Black-box entry subcircuit for sky130_fd_sc_hd__nor3_1 abstract view
.subckt sky130_fd_sc_hd__nor3_1 A B C VGND VNB VPB VPWR Y
.ends

* Black-box entry subcircuit for sky130_fd_sc_hd__o211a_4 abstract view
.subckt sky130_fd_sc_hd__o211a_4 A1 A2 B1 C1 VGND VNB VPB VPWR X
.ends

* Black-box entry subcircuit for sky130_fd_sc_hd__buf_8 abstract view
.subckt sky130_fd_sc_hd__buf_8 A VGND VNB VPB VPWR X
.ends

* Black-box entry subcircuit for sky130_fd_sc_hd__nand3b_4 abstract view
.subckt sky130_fd_sc_hd__nand3b_4 A_N B C VGND VNB VPB VPWR Y
.ends

* Black-box entry subcircuit for sky130_fd_sc_hd__a211oi_1 abstract view
.subckt sky130_fd_sc_hd__a211oi_1 A1 A2 B1 C1 VGND VNB VPB VPWR Y
.ends

* Black-box entry subcircuit for sky130_fd_sc_hd__nand2_4 abstract view
.subckt sky130_fd_sc_hd__nand2_4 A B VGND VNB VPB VPWR Y
.ends

* Black-box entry subcircuit for sky130_fd_sc_hd__nand3_1 abstract view
.subckt sky130_fd_sc_hd__nand3_1 A B C VGND VNB VPB VPWR Y
.ends

* Black-box entry subcircuit for sky130_fd_sc_hd__nor2_2 abstract view
.subckt sky130_fd_sc_hd__nor2_2 A B VGND VNB VPB VPWR Y
.ends

* Black-box entry subcircuit for sky130_fd_sc_hd__a41o_1 abstract view
.subckt sky130_fd_sc_hd__a41o_1 A1 A2 A3 A4 B1 VGND VNB VPB VPWR X
.ends

* Black-box entry subcircuit for sky130_fd_sc_hd__mux2_2 abstract view
.subckt sky130_fd_sc_hd__mux2_2 A0 A1 S VGND VNB VPB VPWR X
.ends

* Black-box entry subcircuit for sky130_fd_sc_hd__and4_2 abstract view
.subckt sky130_fd_sc_hd__and4_2 A B C D VGND VNB VPB VPWR X
.ends

* Black-box entry subcircuit for sky130_fd_sc_hd__or4_1 abstract view
.subckt sky130_fd_sc_hd__or4_1 A B C D VGND VNB VPB VPWR X
.ends

* Black-box entry subcircuit for sky130_fd_sc_hd__a31oi_1 abstract view
.subckt sky130_fd_sc_hd__a31oi_1 A1 A2 A3 B1 VGND VNB VPB VPWR Y
.ends

* Black-box entry subcircuit for sky130_fd_sc_hd__or3_2 abstract view
.subckt sky130_fd_sc_hd__or3_2 A B C VGND VNB VPB VPWR X
.ends

* Black-box entry subcircuit for sky130_fd_sc_hd__and3b_4 abstract view
.subckt sky130_fd_sc_hd__and3b_4 A_N B C VGND VNB VPB VPWR X
.ends

* Black-box entry subcircuit for sky130_fd_sc_hd__a32o_1 abstract view
.subckt sky130_fd_sc_hd__a32o_1 A1 A2 A3 B1 B2 VGND VNB VPB VPWR X
.ends

* Black-box entry subcircuit for sky130_fd_sc_hd__nand3_4 abstract view
.subckt sky130_fd_sc_hd__nand3_4 A B C VGND VNB VPB VPWR Y
.ends

* Black-box entry subcircuit for sky130_fd_sc_hd__and2_4 abstract view
.subckt sky130_fd_sc_hd__and2_4 A B VGND VNB VPB VPWR X
.ends

.subckt lsu_wrapper VGND VPWR arst_i clk count[0] count[10] count[11] count[12] count[13]
+ count[14] count[15] count[16] count[17] count[18] count[19] count[1] count[20] count[21]
+ count[2] count[3] count[4] count[5] count[6] count[7] count[8] count[9] done load_addr[0]
+ load_addr[10] load_addr[11] load_addr[12] load_addr[13] load_addr[14] load_addr[15]
+ load_addr[16] load_addr[17] load_addr[18] load_addr[19] load_addr[1] load_addr[20]
+ load_addr[21] load_addr[2] load_addr[3] load_addr[4] load_addr[5] load_addr[6] load_addr[7]
+ load_addr[8] load_addr[9] load_base_addr[0] load_base_addr[10] load_base_addr[11]
+ load_base_addr[12] load_base_addr[13] load_base_addr[14] load_base_addr[15] load_base_addr[16]
+ load_base_addr[17] load_base_addr[18] load_base_addr[19] load_base_addr[1] load_base_addr[20]
+ load_base_addr[21] load_base_addr[2] load_base_addr[3] load_base_addr[4] load_base_addr[5]
+ load_base_addr[6] load_base_addr[7] load_base_addr[8] load_base_addr[9] load_complete
+ load_data[0] load_data[10] load_data[11] load_data[12] load_data[13] load_data[14]
+ load_data[15] load_data[16] load_data[17] load_data[18] load_data[19] load_data[1]
+ load_data[20] load_data[21] load_data[22] load_data[23] load_data[24] load_data[25]
+ load_data[26] load_data[27] load_data[28] load_data[29] load_data[2] load_data[30]
+ load_data[31] load_data[3] load_data[4] load_data[5] load_data[6] load_data[7] load_data[8]
+ load_data[9] load_req start store_addr[0] store_addr[10] store_addr[11] store_addr[12]
+ store_addr[13] store_addr[14] store_addr[15] store_addr[16] store_addr[17] store_addr[18]
+ store_addr[19] store_addr[1] store_addr[20] store_addr[21] store_addr[2] store_addr[3]
+ store_addr[4] store_addr[5] store_addr[6] store_addr[7] store_addr[8] store_addr[9]
+ store_base_addr[0] store_base_addr[10] store_base_addr[11] store_base_addr[12] store_base_addr[13]
+ store_base_addr[14] store_base_addr[15] store_base_addr[16] store_base_addr[17]
+ store_base_addr[18] store_base_addr[19] store_base_addr[1] store_base_addr[20] store_base_addr[21]
+ store_base_addr[2] store_base_addr[3] store_base_addr[4] store_base_addr[5] store_base_addr[6]
+ store_base_addr[7] store_base_addr[8] store_base_addr[9] store_complete store_data[0]
+ store_data[10] store_data[11] store_data[12] store_data[13] store_data[14] store_data[15]
+ store_data[16] store_data[17] store_data[18] store_data[19] store_data[1] store_data[20]
+ store_data[21] store_data[22] store_data[23] store_data[24] store_data[25] store_data[26]
+ store_data[27] store_data[28] store_data[29] store_data[2] store_data[30] store_data[31]
+ store_data[3] store_data[4] store_data[5] store_data[6] store_data[7] store_data[8]
+ store_data[9] store_req
XFILLER_79_391 VGND VGND VPWR VPWR sky130_fd_sc_hd__fill_1
XFILLER_67_520 VGND VGND VPWR VPWR sky130_fd_sc_hd__decap_6
XFILLER_94_361 VGND VGND VPWR VPWR sky130_fd_sc_hd__decap_3
X_3155_ net658 net323 net180 VGND VGND VPWR VPWR _0657_ sky130_fd_sc_hd__mux2_1
X_2106_ lsu.load_counter\[13\] _1562_ _1593_ VGND VGND VPWR VPWR _1596_ sky130_fd_sc_hd__and3_1
XPHY_EDGE_ROW_6_Left_113 VGND VGND VPWR VPWR sky130_fd_sc_hd__decap_3
X_3086_ net329 net985 net185 VGND VGND VPWR VPWR _0590_ sky130_fd_sc_hd__mux2_1
XFILLER_52_29 VGND VGND VPWR VPWR sky130_fd_sc_hd__decap_3
X_3988_ lsu.load_fifo.queue\[4\]\[1\] lsu.load_fifo.queue\[5\]\[1\] lsu.load_fifo.queue\[6\]\[1\]
+ lsu.load_fifo.queue\[7\]\[1\] net390 net370 VGND VGND VPWR VPWR _1430_ sky130_fd_sc_hd__mux4_1
XFILLER_50_475 VGND VGND VPWR VPWR sky130_fd_sc_hd__fill_1
XTAP_TAPCELL_ROW_79_1100 VGND VPWR sky130_fd_sc_hd__tapvpwrvgnd_1
X_2939_ net353 net787 net214 VGND VGND VPWR VPWR _0450_ sky130_fd_sc_hd__mux2_1
XFILLER_22_177 VGND VGND VPWR VPWR sky130_fd_sc_hd__decap_3
X_4609_ clknet_leaf_68_clk _0666_ VGND VGND VPWR VPWR lsu.load_fifo.queue\[8\]\[25\]
+ sky130_fd_sc_hd__dfxtp_1
XFILLER_89_111 VGND VGND VPWR VPWR sky130_fd_sc_hd__fill_1
Xhold340 lsu.load_fifo.queue\[8\]\[21\] VGND VGND VPWR VPWR net808 sky130_fd_sc_hd__dlygate4sd3_1
Xhold362 lsu.load_fifo.queue\[10\]\[24\] VGND VGND VPWR VPWR net830 sky130_fd_sc_hd__dlygate4sd3_1
Xhold351 lsu.load_fifo.queue\[10\]\[21\] VGND VGND VPWR VPWR net819 sky130_fd_sc_hd__dlygate4sd3_1
XFILLER_89_155 VPWR VGND VPWR VGND sky130_ef_sc_hd__decap_12
Xhold373 lsu.store_fifo.queue\[8\]\[6\] VGND VGND VPWR VPWR net841 sky130_fd_sc_hd__dlygate4sd3_1
Xhold395 lsu.load_fifo.queue\[11\]\[20\] VGND VGND VPWR VPWR net863 sky130_fd_sc_hd__dlygate4sd3_1
Xhold384 lsu.load_fifo.queue\[6\]\[11\] VGND VGND VPWR VPWR net852 sky130_fd_sc_hd__dlygate4sd3_1
XFILLER_77_328 VGND VGND VPWR VPWR sky130_fd_sc_hd__fill_2
XFILLER_45_225 VGND VGND VPWR VPWR sky130_fd_sc_hd__decap_6
XFILLER_93_69 VPWR VGND VPWR VGND sky130_ef_sc_hd__decap_12
XFILLER_14_601 VPWR VGND VPWR VGND sky130_ef_sc_hd__decap_12
XFILLER_26_63 VGND VGND VPWR VPWR sky130_fd_sc_hd__decap_4
XFILLER_13_166 VGND VGND VPWR VPWR sky130_fd_sc_hd__fill_2
XTAP_TAPCELL_ROW_11_356 VGND VPWR sky130_fd_sc_hd__tapvpwrvgnd_1
Xrebuffer7 _1554_ VGND VGND VPWR VPWR net475 sky130_fd_sc_hd__dlygate4sd1_1
XTAP_TAPCELL_ROW_97_1299 VGND VPWR sky130_fd_sc_hd__tapvpwrvgnd_1
XFILLER_5_387 VGND VGND VPWR VPWR sky130_fd_sc_hd__decap_4
XFILLER_68_306 VGND VGND VPWR VPWR sky130_fd_sc_hd__fill_2
XFILLER_95_147 VPWR VGND VPWR VGND sky130_ef_sc_hd__decap_12
XFILLER_95_125 VGND VGND VPWR VPWR sky130_fd_sc_hd__decap_8
XPHY_EDGE_ROW_79_Left_186 VGND VGND VPWR VPWR sky130_fd_sc_hd__decap_3
XFILLER_95_169 VPWR VGND VPWR VGND sky130_ef_sc_hd__decap_12
XFILLER_36_225 VGND VGND VPWR VPWR sky130_fd_sc_hd__decap_4
XTAP_TAPCELL_ROW_19_434 VGND VPWR sky130_fd_sc_hd__tapvpwrvgnd_1
XFILLER_36_269 VGND VGND VPWR VPWR sky130_fd_sc_hd__fill_1
XTAP_TAPCELL_ROW_47_743 VGND VPWR sky130_fd_sc_hd__tapvpwrvgnd_1
XFILLER_17_461 VPWR VGND VPWR VGND sky130_ef_sc_hd__decap_12
X_4960_ clknet_leaf_7_clk _1015_ _0146_ VGND VGND VPWR VPWR acc.byte1\[5\] sky130_fd_sc_hd__dfrtp_1
XFILLER_64_589 VGND VGND VPWR VPWR sky130_fd_sc_hd__decap_3
XTAP_TAPCELL_ROW_106_1395 VGND VPWR sky130_fd_sc_hd__tapvpwrvgnd_1
XFILLER_83_91 VGND VGND VPWR VPWR sky130_fd_sc_hd__decap_4
X_4891_ clknet_leaf_2_clk _0946_ VGND VGND VPWR VPWR lsu.load_fifo.queue\[12\]\[18\]
+ sky130_fd_sc_hd__dfxtp_1
X_3911_ net1267 _1364_ net253 VGND VGND VPWR VPWR _1015_ sky130_fd_sc_hd__mux2_1
XPHY_EDGE_ROW_88_Left_195 VGND VGND VPWR VPWR sky130_fd_sc_hd__decap_3
X_3842_ _1305_ _1302_ net357 VGND VGND VPWR VPWR _1306_ sky130_fd_sc_hd__mux2_1
X_3773_ net290 _1126_ _1245_ VGND VGND VPWR VPWR _1076_ sky130_fd_sc_hd__a21o_1
X_2724_ net841 net278 _2025_ VGND VGND VPWR VPWR _0245_ sky130_fd_sc_hd__mux2_1
X_2655_ net280 net656 _2019_ VGND VGND VPWR VPWR _0182_ sky130_fd_sc_hd__mux2_1
X_2586_ net42 net261 _1976_ VGND VGND VPWR VPWR _1977_ sky130_fd_sc_hd__a21o_1
XTAP_TAPCELL_ROW_74_1041 VGND VPWR sky130_fd_sc_hd__tapvpwrvgnd_1
X_4325_ clknet_leaf_77_clk _0382_ VGND VGND VPWR VPWR lsu.load_fifo.queue\[10\]\[31\]
+ sky130_fd_sc_hd__dfxtp_1
XFILLER_86_114 VGND VGND VPWR VPWR sky130_fd_sc_hd__fill_1
X_4256_ clknet_leaf_57_clk _0313_ VGND VGND VPWR VPWR lsu.store_fifo.queue\[1\]\[4\]
+ sky130_fd_sc_hd__dfxtp_1
X_4187_ clknet_leaf_65_clk _0244_ VGND VGND VPWR VPWR lsu.store_fifo.queue\[8\]\[5\]
+ sky130_fd_sc_hd__dfxtp_1
X_3207_ net288 net1045 _2049_ VGND VGND VPWR VPWR _0718_ sky130_fd_sc_hd__mux2_1
X_3138_ net418 _2039_ net417 VGND VGND VPWR VPWR _2046_ sky130_fd_sc_hd__and3b_2
XFILLER_27_225 VGND VGND VPWR VPWR sky130_fd_sc_hd__decap_4
XFILLER_55_534 VGND VGND VPWR VPWR sky130_fd_sc_hd__fill_2
XFILLER_103_57 VGND VGND VPWR VPWR sky130_fd_sc_hd__decap_6
X_3069_ net559 net296 net208 VGND VGND VPWR VPWR _0574_ sky130_fd_sc_hd__mux2_1
XFILLER_63_39 VGND VGND VPWR VPWR sky130_fd_sc_hd__fill_1
XTAP_TAPCELL_ROW_85_1170 VGND VPWR sky130_fd_sc_hd__tapvpwrvgnd_1
XFILLER_11_615 VGND VGND VPWR VPWR sky130_fd_sc_hd__fill_1
XFILLER_23_453 VGND VGND VPWR VPWR sky130_fd_sc_hd__fill_1
XFILLER_10_158 VGND VGND VPWR VPWR sky130_fd_sc_hd__fill_1
XFILLER_2_357 VGND VGND VPWR VPWR sky130_fd_sc_hd__decap_6
Xhold170 lsu.load_fifo.queue\[8\]\[26\] VGND VGND VPWR VPWR net638 sky130_fd_sc_hd__dlygate4sd3_1
Xhold181 lsu.load_fifo.queue\[11\]\[23\] VGND VGND VPWR VPWR net649 sky130_fd_sc_hd__dlygate4sd3_1
Xhold192 lsu.store_fifo.queue\[10\]\[8\] VGND VGND VPWR VPWR net660 sky130_fd_sc_hd__dlygate4sd3_1
XFILLER_92_139 VGND VGND VPWR VPWR sky130_fd_sc_hd__fill_1
XFILLER_73_353 VGND VGND VPWR VPWR sky130_fd_sc_hd__fill_2
XTAP_TAPCELL_ROW_16_404 VGND VPWR sky130_fd_sc_hd__tapvpwrvgnd_1
XFILLER_18_269 VGND VGND VPWR VPWR sky130_fd_sc_hd__fill_2
XTAP_TAPCELL_ROW_44_713 VGND VPWR sky130_fd_sc_hd__tapvpwrvgnd_1
XTAP_TAPCELL_ROW_99_1317 VGND VPWR sky130_fd_sc_hd__tapvpwrvgnd_1
XFILLER_14_475 VGND VGND VPWR VPWR sky130_fd_sc_hd__fill_1
XTAP_TAPCELL_ROW_24_492 VGND VPWR sky130_fd_sc_hd__tapvpwrvgnd_1
X_2440_ net87 _1870_ net268 VGND VGND VPWR VPWR _1871_ sky130_fd_sc_hd__mux2_1
X_2371_ lsu.store_counter\[3\] _1633_ _1635_ lsu.store_counter\[2\] VGND VGND VPWR
+ VPWR _1810_ sky130_fd_sc_hd__o22a_1
X_4110_ net401 _1538_ net404 VGND VGND VPWR VPWR _1541_ sky130_fd_sc_hd__o21ba_1
XFILLER_96_489 VPWR VGND VPWR VGND sky130_ef_sc_hd__decap_12
X_4041_ lsu.store_fifo.queue\[0\]\[6\] lsu.store_fifo.queue\[1\]\[6\] lsu.store_fifo.queue\[2\]\[6\]
+ lsu.store_fifo.queue\[3\]\[6\] net415 net409 VGND VGND VPWR VPWR _1478_ sky130_fd_sc_hd__mux4_1
XFILLER_56_309 VGND VGND VPWR VPWR sky130_fd_sc_hd__decap_3
XFILLER_49_383 VGND VGND VPWR VPWR sky130_fd_sc_hd__decap_8
XFILLER_37_589 VGND VGND VPWR VPWR sky130_fd_sc_hd__fill_1
XFILLER_52_526 VGND VGND VPWR VPWR sky130_fd_sc_hd__fill_1
XPHY_EDGE_ROW_96_Left_203 VGND VGND VPWR VPWR sky130_fd_sc_hd__decap_3
XFILLER_52_559 VPWR VGND VPWR VGND sky130_ef_sc_hd__decap_12
X_4943_ clknet_leaf_48_clk _0998_ _0129_ VGND VGND VPWR VPWR net155 sky130_fd_sc_hd__dfrtp_1
XFILLER_32_250 VGND VGND VPWR VPWR sky130_fd_sc_hd__fill_2
XFILLER_20_401 VGND VGND VPWR VPWR sky130_fd_sc_hd__decap_8
X_4874_ clknet_leaf_77_clk _0929_ VGND VGND VPWR VPWR lsu.load_fifo.queue\[12\]\[1\]
+ sky130_fd_sc_hd__dfxtp_1
X_3825_ lsu.load_fifo.queue\[12\]\[25\] lsu.load_fifo.queue\[13\]\[25\] lsu.load_fifo.queue\[14\]\[25\]
+ lsu.load_fifo.queue\[15\]\[25\] net388 net371 VGND VGND VPWR VPWR _1291_ sky130_fd_sc_hd__mux4_1
X_3756_ _1180_ _1228_ VGND VGND VPWR VPWR _1235_ sky130_fd_sc_hd__or2_1
X_2707_ net289 net981 _2023_ VGND VGND VPWR VPWR _0230_ sky130_fd_sc_hd__mux2_1
XFILLER_106_539 VGND VGND VPWR VPWR sky130_fd_sc_hd__fill_1
XFILLER_106_517 VGND VGND VPWR VPWR sky130_fd_sc_hd__decap_4
X_3687_ _1166_ _1168_ _1165_ VGND VGND VPWR VPWR _1169_ sky130_fd_sc_hd__a21bo_1
X_2638_ lsu.store_fifo.w_ptr\[3\] _1115_ VGND VGND VPWR VPWR _2014_ sky130_fd_sc_hd__or2_2
X_2569_ lsu.current_load_addr\[10\] _1925_ VGND VGND VPWR VPWR _1964_ sky130_fd_sc_hd__or2_1
XFILLER_87_401 VGND VGND VPWR VPWR sky130_fd_sc_hd__decap_3
XFILLER_87_445 VGND VGND VPWR VPWR sky130_fd_sc_hd__decap_3
X_4308_ clknet_leaf_3_clk _0365_ VGND VGND VPWR VPWR lsu.load_fifo.queue\[10\]\[14\]
+ sky130_fd_sc_hd__dfxtp_1
X_4239_ clknet_leaf_67_clk _0296_ VGND VGND VPWR VPWR lsu.store_fifo.queue\[3\]\[7\]
+ sky130_fd_sc_hd__dfxtp_1
XFILLER_47_309 VPWR VGND VPWR VGND sky130_ef_sc_hd__decap_12
XFILLER_59_169 VGND VGND VPWR VPWR sky130_fd_sc_hd__decap_4
XFILLER_74_139 VGND VGND VPWR VPWR sky130_fd_sc_hd__fill_1
XFILLER_74_27 VGND VGND VPWR VPWR sky130_fd_sc_hd__fill_1
XFILLER_82_150 VGND VGND VPWR VPWR sky130_fd_sc_hd__decap_4
XFILLER_28_589 VPWR VGND VPWR VGND sky130_ef_sc_hd__decap_12
XFILLER_43_559 VGND VGND VPWR VPWR sky130_fd_sc_hd__fill_1
XFILLER_90_15 VPWR VGND VPWR VGND sky130_ef_sc_hd__decap_12
XFILLER_23_53 VGND VGND VPWR VPWR sky130_fd_sc_hd__decap_3
XFILLER_7_449 VPWR VGND VPWR VGND sky130_ef_sc_hd__decap_12
XTAP_TAPCELL_ROW_21_462 VGND VPWR sky130_fd_sc_hd__tapvpwrvgnd_1
XFILLER_99_57 VPWR VGND VPWR VGND sky130_ef_sc_hd__decap_12
XTAP_TAPCELL_ROW_94_1269 VGND VPWR sky130_fd_sc_hd__tapvpwrvgnd_1
XFILLER_78_412 VGND VGND VPWR VPWR sky130_fd_sc_hd__decap_3
XFILLER_0_57 VPWR VGND VPWR VGND sky130_ef_sc_hd__decap_12
XTAP_TAPCELL_ROW_29_551 VGND VPWR sky130_fd_sc_hd__tapvpwrvgnd_1
XTAP_TAPCELL_ROW_57_860 VGND VPWR sky130_fd_sc_hd__tapvpwrvgnd_1
XTAP_TAPCELL_ROW_103_1365 VGND VPWR sky130_fd_sc_hd__tapvpwrvgnd_1
XFILLER_14_272 VGND VGND VPWR VPWR sky130_fd_sc_hd__decap_3
XPHY_EDGE_ROW_104_Right_104 VGND VGND VPWR VPWR sky130_fd_sc_hd__decap_3
X_4590_ clknet_leaf_1_clk _0647_ VGND VGND VPWR VPWR lsu.load_fifo.queue\[8\]\[6\]
+ sky130_fd_sc_hd__dfxtp_1
X_3610_ net430 VGND VGND VPWR VPWR _0174_ sky130_fd_sc_hd__inv_2
X_3541_ net437 VGND VGND VPWR VPWR _0105_ sky130_fd_sc_hd__inv_2
X_3472_ net428 VGND VGND VPWR VPWR _0036_ sky130_fd_sc_hd__inv_2
XFILLER_50_3 VGND VGND VPWR VPWR sky130_fd_sc_hd__decap_3
XFILLER_103_509 VGND VGND VPWR VPWR sky130_fd_sc_hd__fill_1
X_2423_ net1301 _1724_ _1839_ _1858_ VGND VGND VPWR VPWR _0810_ sky130_fd_sc_hd__a22o_1
XTAP_TAPCELL_ROW_71_1011 VGND VPWR sky130_fd_sc_hd__tapvpwrvgnd_1
X_2354_ lsu.store_counter\[13\] _1594_ _1792_ VGND VGND VPWR VPWR _1793_ sky130_fd_sc_hd__o21a_1
XFILLER_69_445 VGND VGND VPWR VPWR sky130_fd_sc_hd__decap_3
XFILLER_96_253 VPWR VGND VPWR VGND sky130_ef_sc_hd__decap_12
X_2285_ lsu.store_counter\[16\] net241 _1732_ lsu.store_counter\[17\] VGND VGND VPWR
+ VPWR _1745_ sky130_fd_sc_hd__a31o_1
XFILLER_84_448 VGND VGND VPWR VPWR sky130_fd_sc_hd__decap_8
X_4024_ lsu.store_fifo.queue\[12\]\[8\] lsu.store_fifo.queue\[13\]\[8\] lsu.store_fifo.queue\[14\]\[8\]
+ lsu.store_fifo.queue\[15\]\[8\] net414 net410 VGND VGND VPWR VPWR _1463_ sky130_fd_sc_hd__mux4_1
XFILLER_25_537 VPWR VGND VPWR VGND sky130_ef_sc_hd__decap_12
X_4926_ clknet_leaf_27_clk _0981_ VGND VGND VPWR VPWR lsu.load_fifo.queue\[13\]\[21\]
+ sky130_fd_sc_hd__dfxtp_1
X_4857_ clknet_leaf_40_clk _0912_ _0107_ VGND VGND VPWR VPWR lsu.load_counter\[7\]
+ sky130_fd_sc_hd__dfrtp_1
XFILLER_60_18 VGND VGND VPWR VPWR sky130_fd_sc_hd__fill_2
X_3808_ lsu.load_fifo.queue\[8\]\[27\] lsu.load_fifo.queue\[9\]\[27\] lsu.load_fifo.queue\[10\]\[27\]
+ lsu.load_fifo.queue\[11\]\[27\] net387 net370 VGND VGND VPWR VPWR _1276_ sky130_fd_sc_hd__mux4_1
X_4788_ clknet_leaf_57_clk _0845_ VGND VGND VPWR VPWR lsu.store_fifo.queue\[0\]\[8\]
+ sky130_fd_sc_hd__dfxtp_1
XFILLER_4_419 VGND VGND VPWR VPWR sky130_fd_sc_hd__fill_1
X_3739_ _1212_ _1220_ VGND VGND VPWR VPWR _1221_ sky130_fd_sc_hd__nand2b_1
XFILLER_102_531 VGND VGND VPWR VPWR sky130_fd_sc_hd__fill_1
XFILLER_102_553 VPWR VGND VPWR VGND sky130_ef_sc_hd__decap_12
XFILLER_62_109 VGND VGND VPWR VPWR sky130_fd_sc_hd__decap_6
XTAP_TAPCELL_ROW_26_521 VGND VPWR sky130_fd_sc_hd__tapvpwrvgnd_1
XFILLER_70_131 VGND VGND VPWR VPWR sky130_fd_sc_hd__fill_1
XFILLER_34_85 VGND VGND VPWR VPWR sky130_fd_sc_hd__decap_4
XFILLER_7_279 VGND VGND VPWR VPWR sky130_fd_sc_hd__fill_1
XFILLER_50_95 VGND VGND VPWR VPWR sky130_fd_sc_hd__decap_4
XFILLER_3_441 VGND VGND VPWR VPWR sky130_fd_sc_hd__decap_6
XFILLER_3_485 VPWR VGND VPWR VGND sky130_ef_sc_hd__decap_12
XFILLER_105_391 VGND VGND VPWR VPWR sky130_fd_sc_hd__fill_1
XFILLER_66_437 VGND VGND VPWR VPWR sky130_fd_sc_hd__decap_6
XFILLER_38_106 VGND VGND VPWR VPWR sky130_fd_sc_hd__fill_2
X_2070_ _1121_ _1122_ _1123_ _1557_ VGND VGND VPWR VPWR _1560_ sky130_fd_sc_hd__and4_1
XFILLER_93_223 VGND VGND VPWR VPWR sky130_fd_sc_hd__fill_1
XFILLER_34_312 VGND VGND VPWR VPWR sky130_fd_sc_hd__decap_3
XFILLER_34_345 VGND VGND VPWR VPWR sky130_fd_sc_hd__decap_3
XFILLER_98_3 VPWR VGND VPWR VGND sky130_ef_sc_hd__decap_12
X_2972_ net416 net418 _2039_ VGND VGND VPWR VPWR _2040_ sky130_fd_sc_hd__and3b_2
X_4711_ clknet_leaf_25_clk _0768_ VGND VGND VPWR VPWR net118 sky130_fd_sc_hd__dfxtp_1
XTAP_TAPCELL_ROW_32_579 VGND VPWR sky130_fd_sc_hd__tapvpwrvgnd_1
X_4642_ clknet_leaf_17_clk _0699_ VGND VGND VPWR VPWR lsu.load_fifo.queue\[15\]\[26\]
+ sky130_fd_sc_hd__dfxtp_1
XTAP_TAPCELL_ROW_60_888 VGND VPWR sky130_fd_sc_hd__tapvpwrvgnd_1
X_4573_ clknet_leaf_14_clk _0630_ VGND VGND VPWR VPWR lsu.load_fifo.queue\[0\]\[21\]
+ sky130_fd_sc_hd__dfxtp_1
Xhold703 lsu.load_fifo.queue\[1\]\[6\] VGND VGND VPWR VPWR net1171 sky130_fd_sc_hd__dlygate4sd3_1
X_3524_ net440 VGND VGND VPWR VPWR _0088_ sky130_fd_sc_hd__inv_2
Xhold736 lsu.load_fifo.queue\[5\]\[3\] VGND VGND VPWR VPWR net1204 sky130_fd_sc_hd__dlygate4sd3_1
Xhold725 lsu.store_fifo.queue\[9\]\[3\] VGND VGND VPWR VPWR net1193 sky130_fd_sc_hd__dlygate4sd3_1
Xhold714 lsu.load_fifo.queue\[9\]\[19\] VGND VGND VPWR VPWR net1182 sky130_fd_sc_hd__dlygate4sd3_1
X_3455_ net426 VGND VGND VPWR VPWR _0019_ sky130_fd_sc_hd__inv_2
Xhold769 lsu.load_fifo.queue\[0\]\[17\] VGND VGND VPWR VPWR net1237 sky130_fd_sc_hd__dlygate4sd3_1
Xhold758 lsu.store_fifo.queue\[7\]\[1\] VGND VGND VPWR VPWR net1226 sky130_fd_sc_hd__dlygate4sd3_1
Xhold747 lsu.store_fifo.queue\[15\]\[9\] VGND VGND VPWR VPWR net1215 sky130_fd_sc_hd__dlygate4sd3_1
X_2406_ lsu.current_store_addr\[3\] lsu.current_store_addr\[2\] lsu.current_store_addr\[1\]
+ lsu.current_store_addr\[0\] VGND VGND VPWR VPWR _1842_ sky130_fd_sc_hd__and4_1
XFILLER_97_540 VGND VGND VPWR VPWR sky130_fd_sc_hd__decap_4
X_3386_ net905 net350 net200 VGND VGND VPWR VPWR _1036_ sky130_fd_sc_hd__mux2_1
X_2337_ net419 _1254_ _1772_ _1775_ _1776_ VGND VGND VPWR VPWR _1777_ sky130_fd_sc_hd__o2111a_1
XFILLER_57_415 VGND VGND VPWR VPWR sky130_fd_sc_hd__fill_1
X_2268_ lsu.store_counter\[17\] lsu.store_counter\[16\] _1732_ VGND VGND VPWR VPWR
+ _1733_ sky130_fd_sc_hd__and3_1
XFILLER_57_459 VGND VGND VPWR VPWR sky130_fd_sc_hd__decap_6
XTAP_TAPCELL_ROW_68_977 VGND VPWR sky130_fd_sc_hd__tapvpwrvgnd_1
X_4007_ _1445_ _1446_ lsu.store_fifo.r_en VGND VGND VPWR VPWR _1447_ sky130_fd_sc_hd__a21boi_2
X_2199_ _1098_ _1675_ VGND VGND VPWR VPWR _1685_ sky130_fd_sc_hd__and2_1
XFILLER_13_529 VPWR VGND VPWR VGND sky130_ef_sc_hd__decap_12
X_4909_ clknet_leaf_18_clk _0964_ VGND VGND VPWR VPWR lsu.load_fifo.queue\[13\]\[4\]
+ sky130_fd_sc_hd__dfxtp_1
XFILLER_106_133 VGND VGND VPWR VPWR sky130_fd_sc_hd__decap_3
XTAP_TAPCELL_ROW_91_1228 VGND VPWR sky130_fd_sc_hd__tapvpwrvgnd_1
XFILLER_0_433 VPWR VGND VPWR VGND sky130_ef_sc_hd__decap_12
XFILLER_0_477 VPWR VGND VPWR VGND sky130_ef_sc_hd__decap_12
XPHY_EDGE_ROW_42_Left_149 VGND VGND VPWR VPWR sky130_fd_sc_hd__decap_3
Xhold41 lsu.store_fifo.queue\[10\]\[4\] VGND VGND VPWR VPWR net509 sky130_fd_sc_hd__dlygate4sd3_1
Xhold63 lsu.store_fifo.queue\[4\]\[6\] VGND VGND VPWR VPWR net531 sky130_fd_sc_hd__dlygate4sd3_1
Xhold52 lsu.store_fifo.queue\[10\]\[0\] VGND VGND VPWR VPWR net520 sky130_fd_sc_hd__dlygate4sd3_1
Xhold74 lsu.load_fifo.queue\[10\]\[12\] VGND VGND VPWR VPWR net542 sky130_fd_sc_hd__dlygate4sd3_1
Xhold85 lsu.load_fifo.queue\[8\]\[24\] VGND VGND VPWR VPWR net553 sky130_fd_sc_hd__dlygate4sd3_1
Xhold96 lsu.load_fifo.queue\[3\]\[9\] VGND VGND VPWR VPWR net564 sky130_fd_sc_hd__dlygate4sd3_1
XTAP_TAPCELL_ROW_3_260 VGND VPWR sky130_fd_sc_hd__tapvpwrvgnd_1
XFILLER_75_289 VGND VGND VPWR VPWR sky130_fd_sc_hd__decap_4
XFILLER_44_621 VGND VGND VPWR VPWR sky130_fd_sc_hd__fill_1
XFILLER_45_73 VGND VGND VPWR VPWR sky130_fd_sc_hd__fill_2
XFILLER_71_473 VPWR VGND VPWR VGND sky130_ef_sc_hd__decap_12
XFILLER_31_337 VPWR VGND VPWR VGND sky130_ef_sc_hd__decap_12
XPHY_EDGE_ROW_51_Left_158 VGND VGND VPWR VPWR sky130_fd_sc_hd__decap_3
XTAP_TAPCELL_ROW_100_1335 VGND VPWR sky130_fd_sc_hd__tapvpwrvgnd_1
XFILLER_8_533 VPWR VGND VPWR VGND sky130_ef_sc_hd__decap_12
XANTENNA_5 lsu.current_load_addr\[7\] VGND VGND VPWR VPWR sky130_fd_sc_hd__diode_2
X_3240_ net607 lsu.current_load_addr\[12\] net237 VGND VGND VPWR VPWR _0778_ sky130_fd_sc_hd__mux2_1
XPHY_EDGE_ROW_60_Left_167 VGND VGND VPWR VPWR sky130_fd_sc_hd__decap_3
XFILLER_100_309 VGND VGND VPWR VPWR sky130_fd_sc_hd__decap_8
X_3171_ net416 net418 _1998_ VGND VGND VPWR VPWR _2047_ sky130_fd_sc_hd__and3_2
XFILLER_79_573 VPWR VGND VPWR VGND sky130_ef_sc_hd__decap_12
X_2122_ _1124_ _1556_ VGND VGND VPWR VPWR _1612_ sky130_fd_sc_hd__xnor2_2
XFILLER_94_521 VGND VGND VPWR VPWR sky130_fd_sc_hd__fill_1
XFILLER_13_3 VPWR VGND VPWR VGND sky130_ef_sc_hd__decap_12
XFILLER_66_245 VGND VGND VPWR VPWR sky130_fd_sc_hd__fill_1
XFILLER_19_150 VGND VGND VPWR VPWR sky130_fd_sc_hd__fill_2
XFILLER_26_109 VGND VGND VPWR VPWR sky130_fd_sc_hd__decap_8
XFILLER_35_621 VGND VGND VPWR VPWR sky130_fd_sc_hd__fill_1
XTAP_TAPCELL_ROW_37_638 VGND VPWR sky130_fd_sc_hd__tapvpwrvgnd_1
XFILLER_54_429 VGND VGND VPWR VPWR sky130_fd_sc_hd__decap_4
XTAP_TAPCELL_ROW_65_947 VGND VPWR sky130_fd_sc_hd__tapvpwrvgnd_1
XFILLER_34_131 VGND VGND VPWR VPWR sky130_fd_sc_hd__decap_8
X_2955_ net320 net938 net215 VGND VGND VPWR VPWR _0466_ sky130_fd_sc_hd__mux2_1
X_2886_ net856 net326 net193 VGND VGND VPWR VPWR _0397_ sky130_fd_sc_hd__mux2_1
X_4625_ clknet_leaf_83_clk _0682_ VGND VGND VPWR VPWR lsu.load_fifo.queue\[15\]\[9\]
+ sky130_fd_sc_hd__dfxtp_1
Xhold511 lsu.load_fifo.queue\[9\]\[7\] VGND VGND VPWR VPWR net979 sky130_fd_sc_hd__dlygate4sd3_1
X_4556_ clknet_leaf_17_clk _0613_ VGND VGND VPWR VPWR lsu.load_fifo.queue\[0\]\[4\]
+ sky130_fd_sc_hd__dfxtp_1
Xhold500 lsu.load_fifo.queue\[5\]\[30\] VGND VGND VPWR VPWR net968 sky130_fd_sc_hd__dlygate4sd3_1
X_3507_ net438 VGND VGND VPWR VPWR _0071_ sky130_fd_sc_hd__inv_2
Xhold522 lsu.load_fifo.queue\[5\]\[29\] VGND VGND VPWR VPWR net990 sky130_fd_sc_hd__dlygate4sd3_1
XTAP_TAPCELL_ROW_77_1072 VGND VPWR sky130_fd_sc_hd__tapvpwrvgnd_1
Xhold544 lsu.store_fifo.queue\[3\]\[6\] VGND VGND VPWR VPWR net1012 sky130_fd_sc_hd__dlygate4sd3_1
Xhold533 lsu.load_fifo.queue\[13\]\[4\] VGND VGND VPWR VPWR net1001 sky130_fd_sc_hd__dlygate4sd3_1
XFILLER_1_208 VPWR VGND VPWR VGND sky130_ef_sc_hd__decap_12
Xhold566 lsu.load_fifo.queue\[10\]\[11\] VGND VGND VPWR VPWR net1034 sky130_fd_sc_hd__dlygate4sd3_1
Xhold588 lsu.load_fifo.queue\[10\]\[1\] VGND VGND VPWR VPWR net1056 sky130_fd_sc_hd__dlygate4sd3_1
X_4487_ clknet_leaf_76_clk _0544_ VGND VGND VPWR VPWR lsu.load_fifo.queue\[3\]\[31\]
+ sky130_fd_sc_hd__dfxtp_1
Xhold555 lsu.store_fifo.queue\[13\]\[2\] VGND VGND VPWR VPWR net1023 sky130_fd_sc_hd__dlygate4sd3_1
Xhold577 lsu.store_fifo.queue\[15\]\[1\] VGND VGND VPWR VPWR net1045 sky130_fd_sc_hd__dlygate4sd3_1
Xhold599 lsu.load_fifo.queue\[15\]\[24\] VGND VGND VPWR VPWR net1067 sky130_fd_sc_hd__dlygate4sd3_1
X_3438_ _1106_ _1258_ _1712_ VGND VGND VPWR VPWR _0000_ sky130_fd_sc_hd__and3_1
XFILLER_103_169 VGND VGND VPWR VPWR sky130_fd_sc_hd__decap_4
X_3369_ net318 net1222 net169 VGND VGND VPWR VPWR _0978_ sky130_fd_sc_hd__mux2_1
XFILLER_57_234 VGND VGND VPWR VPWR sky130_fd_sc_hd__fill_2
XFILLER_57_278 VGND VGND VPWR VPWR sky130_fd_sc_hd__fill_2
XTAP_TAPCELL_ROW_0_230 VGND VPWR sky130_fd_sc_hd__tapvpwrvgnd_1
X_5039_ clknet_leaf_49_clk _1094_ VGND VGND VPWR VPWR lsu.store_fifo.queue\[12\]\[8\]
+ sky130_fd_sc_hd__dfxtp_1
XFILLER_82_27 VGND VGND VPWR VPWR sky130_fd_sc_hd__fill_1
XFILLER_15_87 VGND VGND VPWR VPWR sky130_fd_sc_hd__decap_4
XFILLER_5_503 VGND VGND VPWR VPWR sky130_fd_sc_hd__fill_1
XFILLER_95_329 VGND VGND VPWR VPWR sky130_fd_sc_hd__decap_6
XFILLER_102_180 VGND VGND VPWR VPWR sky130_fd_sc_hd__fill_1
XFILLER_76_543 VGND VGND VPWR VPWR sky130_fd_sc_hd__fill_2
XFILLER_16_153 VGND VGND VPWR VPWR sky130_fd_sc_hd__decap_3
XFILLER_31_101 VGND VGND VPWR VPWR sky130_fd_sc_hd__fill_2
XTAP_TAPCELL_ROW_34_608 VGND VPWR sky130_fd_sc_hd__tapvpwrvgnd_1
XTAP_TAPCELL_ROW_62_917 VGND VPWR sky130_fd_sc_hd__tapvpwrvgnd_1
XFILLER_71_281 VGND VGND VPWR VPWR sky130_fd_sc_hd__decap_8
XTAP_TAPCELL_ROW_14_387 VGND VPWR sky130_fd_sc_hd__tapvpwrvgnd_1
X_2740_ net890 net288 _2026_ VGND VGND VPWR VPWR _0260_ sky130_fd_sc_hd__mux2_1
XTAP_TAPCELL_ROW_42_696 VGND VPWR sky130_fd_sc_hd__tapvpwrvgnd_1
X_2671_ net692 net273 _2021_ VGND VGND VPWR VPWR _0196_ sky130_fd_sc_hd__mux2_1
X_4410_ clknet_leaf_1_clk _0467_ VGND VGND VPWR VPWR lsu.load_fifo.queue\[5\]\[18\]
+ sky130_fd_sc_hd__dfxtp_1
X_4341_ clknet_leaf_11_clk _0398_ VGND VGND VPWR VPWR lsu.load_fifo.queue\[7\]\[15\]
+ sky130_fd_sc_hd__dfxtp_1
X_4272_ clknet_leaf_24_clk _0329_ VGND VGND VPWR VPWR lsu.load_fifo.queue\[9\]\[10\]
+ sky130_fd_sc_hd__dfxtp_1
Xfanout309 lsu.load_fifo.data_in\[23\] VGND VGND VPWR VPWR net309 sky130_fd_sc_hd__clkbuf_2
X_3223_ net693 net278 _2050_ VGND VGND VPWR VPWR _0759_ sky130_fd_sc_hd__mux2_1
XFILLER_67_543 VPWR VGND VPWR VGND sky130_ef_sc_hd__decap_12
X_3154_ net835 net324 net180 VGND VGND VPWR VPWR _0656_ sky130_fd_sc_hd__mux2_1
X_2105_ _1562_ _1593_ lsu.load_counter\[13\] VGND VGND VPWR VPWR _1595_ sky130_fd_sc_hd__a21o_1
XFILLER_27_418 VGND VGND VPWR VPWR sky130_fd_sc_hd__fill_2
X_3085_ net331 net1191 net187 VGND VGND VPWR VPWR _0589_ sky130_fd_sc_hd__mux2_1
XFILLER_82_557 VGND VGND VPWR VPWR sky130_fd_sc_hd__decap_4
XFILLER_23_602 VPWR VGND VPWR VGND sky130_ef_sc_hd__decap_12
XFILLER_50_421 VGND VGND VPWR VPWR sky130_fd_sc_hd__fill_1
X_3987_ net1308 _1429_ net254 VGND VGND VPWR VPWR _1004_ sky130_fd_sc_hd__mux2_1
XFILLER_10_307 VGND VGND VPWR VPWR sky130_fd_sc_hd__fill_1
X_2938_ net354 net1146 net217 VGND VGND VPWR VPWR _0449_ sky130_fd_sc_hd__mux2_1
XTAP_TAPCELL_ROW_79_1101 VGND VPWR sky130_fd_sc_hd__tapvpwrvgnd_1
X_2869_ net1014 net297 net224 VGND VGND VPWR VPWR _0380_ sky130_fd_sc_hd__mux2_1
X_4608_ clknet_leaf_37_clk _0665_ VGND VGND VPWR VPWR lsu.load_fifo.queue\[8\]\[24\]
+ sky130_fd_sc_hd__dfxtp_1
Xhold330 lsu.load_fifo.queue\[6\]\[2\] VGND VGND VPWR VPWR net798 sky130_fd_sc_hd__dlygate4sd3_1
X_4539_ clknet_leaf_77_clk _0596_ VGND VGND VPWR VPWR lsu.load_fifo.queue\[1\]\[19\]
+ sky130_fd_sc_hd__dfxtp_1
Xhold341 lsu.store_fifo.queue\[12\]\[9\] VGND VGND VPWR VPWR net809 sky130_fd_sc_hd__dlygate4sd3_1
Xhold352 lsu.load_fifo.queue\[3\]\[13\] VGND VGND VPWR VPWR net820 sky130_fd_sc_hd__dlygate4sd3_1
Xhold396 lsu.load_fifo.queue\[2\]\[14\] VGND VGND VPWR VPWR net864 sky130_fd_sc_hd__dlygate4sd3_1
Xhold385 lsu.load_fifo.queue\[0\]\[18\] VGND VGND VPWR VPWR net853 sky130_fd_sc_hd__dlygate4sd3_1
Xhold363 lsu.load_fifo.queue\[11\]\[22\] VGND VGND VPWR VPWR net831 sky130_fd_sc_hd__dlygate4sd3_1
Xhold374 lsu.load_fifo.queue\[0\]\[4\] VGND VGND VPWR VPWR net842 sky130_fd_sc_hd__dlygate4sd3_1
XFILLER_89_167 VGND VGND VPWR VPWR sky130_fd_sc_hd__fill_1
XFILLER_93_15 VPWR VGND VPWR VGND sky130_ef_sc_hd__decap_12
XFILLER_18_418 VGND VGND VPWR VPWR sky130_fd_sc_hd__fill_2
XFILLER_45_248 VGND VGND VPWR VPWR sky130_fd_sc_hd__decap_6
Xclkbuf_3_6__f_clk clknet_0_clk VGND VGND VPWR VPWR clknet_3_6__leaf_clk sky130_fd_sc_hd__clkbuf_16
XFILLER_14_613 VPWR VGND VPWR VGND sky130_ef_sc_hd__decap_12
XFILLER_26_473 VGND VGND VPWR VPWR sky130_fd_sc_hd__decap_3
XFILLER_53_292 VGND VGND VPWR VPWR sky130_fd_sc_hd__fill_2
XTAP_TAPCELL_ROW_11_346 VGND VPWR sky130_fd_sc_hd__tapvpwrvgnd_1
XFILLER_42_85 VGND VGND VPWR VPWR sky130_fd_sc_hd__decap_6
XFILLER_1_561 VPWR VGND VPWR VGND sky130_ef_sc_hd__decap_12
XFILLER_3_57 VPWR VGND VPWR VGND sky130_ef_sc_hd__decap_12
XFILLER_95_159 VGND VGND VPWR VPWR sky130_fd_sc_hd__decap_8
XTAP_TAPCELL_ROW_19_435 VGND VPWR sky130_fd_sc_hd__tapvpwrvgnd_1
XTAP_TAPCELL_ROW_47_744 VGND VPWR sky130_fd_sc_hd__tapvpwrvgnd_1
XFILLER_17_473 VPWR VGND VPWR VGND sky130_ef_sc_hd__decap_12
XFILLER_51_218 VGND VGND VPWR VPWR sky130_fd_sc_hd__decap_6
XTAP_TAPCELL_ROW_106_1396 VGND VPWR sky130_fd_sc_hd__tapvpwrvgnd_1
X_4890_ clknet_leaf_69_clk _0945_ VGND VGND VPWR VPWR lsu.load_fifo.queue\[12\]\[17\]
+ sky130_fd_sc_hd__dfxtp_1
XFILLER_32_421 VGND VGND VPWR VPWR sky130_fd_sc_hd__decap_3
X_3910_ _1363_ _1360_ net356 VGND VGND VPWR VPWR _1364_ sky130_fd_sc_hd__mux2_1
X_3841_ _1304_ _1303_ net361 VGND VGND VPWR VPWR _1305_ sky130_fd_sc_hd__mux2_1
XFILLER_80_3 VGND VGND VPWR VPWR sky130_fd_sc_hd__decap_8
X_3772_ _1244_ _1125_ _1218_ VGND VGND VPWR VPWR _1245_ sky130_fd_sc_hd__and3b_1
X_2723_ net1200 net280 _2025_ VGND VGND VPWR VPWR _0244_ sky130_fd_sc_hd__mux2_1
Xlsu_wrapper_460 VGND VGND VPWR VPWR lsu_wrapper_460/HI store_data[23] sky130_fd_sc_hd__conb_1
X_2654_ net283 net1024 _2019_ VGND VGND VPWR VPWR _0181_ sky130_fd_sc_hd__mux2_1
X_2585_ _1923_ _1975_ net264 VGND VGND VPWR VPWR _1976_ sky130_fd_sc_hd__and3b_1
XFILLER_99_432 VPWR VGND VPWR VGND sky130_ef_sc_hd__decap_12
XTAP_TAPCELL_ROW_74_1042 VGND VPWR sky130_fd_sc_hd__tapvpwrvgnd_1
X_4324_ clknet_leaf_12_clk _0381_ VGND VGND VPWR VPWR lsu.load_fifo.queue\[10\]\[30\]
+ sky130_fd_sc_hd__dfxtp_1
X_4255_ clknet_leaf_67_clk _0312_ VGND VGND VPWR VPWR lsu.store_fifo.queue\[1\]\[3\]
+ sky130_fd_sc_hd__dfxtp_1
X_4186_ clknet_leaf_61_clk _0243_ VGND VGND VPWR VPWR lsu.store_fifo.queue\[8\]\[4\]
+ sky130_fd_sc_hd__dfxtp_1
X_3206_ net290 net664 _2049_ VGND VGND VPWR VPWR _0717_ sky130_fd_sc_hd__mux2_1
X_3137_ net545 net292 net182 VGND VGND VPWR VPWR _0640_ sky130_fd_sc_hd__mux2_1
XFILLER_82_321 VGND VGND VPWR VPWR sky130_fd_sc_hd__decap_4
XFILLER_55_557 VGND VGND VPWR VPWR sky130_fd_sc_hd__decap_3
X_3068_ net535 net298 net208 VGND VGND VPWR VPWR _0573_ sky130_fd_sc_hd__mux2_1
XTAP_TAPCELL_ROW_85_1160 VGND VPWR sky130_fd_sc_hd__tapvpwrvgnd_1
XFILLER_35_281 VGND VGND VPWR VPWR sky130_fd_sc_hd__decap_4
XFILLER_23_443 VGND VGND VPWR VPWR sky130_fd_sc_hd__decap_4
XFILLER_12_11 VGND VGND VPWR VPWR sky130_fd_sc_hd__fill_1
XFILLER_7_609 VGND VGND VPWR VPWR sky130_fd_sc_hd__decap_6
XFILLER_88_15 VPWR VGND VPWR VGND sky130_ef_sc_hd__decap_12
Xhold171 lsu.load_fifo.queue\[7\]\[17\] VGND VGND VPWR VPWR net639 sky130_fd_sc_hd__dlygate4sd3_1
Xhold160 lsu.load_fifo.queue\[3\]\[19\] VGND VGND VPWR VPWR net628 sky130_fd_sc_hd__dlygate4sd3_1
Xhold182 lsu.load_fifo.queue\[12\]\[8\] VGND VGND VPWR VPWR net650 sky130_fd_sc_hd__dlygate4sd3_1
Xhold193 lsu.store_fifo.queue\[4\]\[0\] VGND VGND VPWR VPWR net661 sky130_fd_sc_hd__dlygate4sd3_1
XFILLER_37_63 VGND VGND VPWR VPWR sky130_fd_sc_hd__fill_1
XTAP_TAPCELL_ROW_16_405 VGND VPWR sky130_fd_sc_hd__tapvpwrvgnd_1
XTAP_TAPCELL_ROW_44_714 VGND VPWR sky130_fd_sc_hd__tapvpwrvgnd_1
XFILLER_61_505 VGND VGND VPWR VPWR sky130_fd_sc_hd__decap_4
XFILLER_14_421 VPWR VGND VPWR VGND sky130_ef_sc_hd__decap_12
XFILLER_14_410 VGND VGND VPWR VPWR sky130_fd_sc_hd__decap_8
XFILLER_41_251 VPWR VGND VPWR VGND sky130_ef_sc_hd__decap_12
XTAP_TAPCELL_ROW_99_1318 VGND VPWR sky130_fd_sc_hd__tapvpwrvgnd_1
XTAP_TAPCELL_ROW_24_493 VGND VPWR sky130_fd_sc_hd__tapvpwrvgnd_1
X_2370_ lsu.store_counter\[3\] _1633_ VGND VGND VPWR VPWR _1809_ sky130_fd_sc_hd__nand2_1
XFILLER_68_137 VGND VGND VPWR VPWR sky130_fd_sc_hd__decap_3
XFILLER_96_468 VGND VGND VPWR VPWR sky130_fd_sc_hd__fill_2
XFILLER_1_391 VGND VGND VPWR VPWR sky130_fd_sc_hd__fill_1
X_4040_ net1241 net246 _1477_ VGND VGND VPWR VPWR _0999_ sky130_fd_sc_hd__o21a_1
XFILLER_76_170 VGND VGND VPWR VPWR sky130_fd_sc_hd__fill_2
X_4942_ clknet_leaf_63_clk _0997_ _0128_ VGND VGND VPWR VPWR net154 sky130_fd_sc_hd__dfrtp_1
X_4873_ clknet_leaf_35_clk _0928_ VGND VGND VPWR VPWR lsu.load_fifo.queue\[12\]\[0\]
+ sky130_fd_sc_hd__dfxtp_1
X_3824_ _1289_ _1288_ net361 VGND VGND VPWR VPWR _1290_ sky130_fd_sc_hd__mux2_1
X_3755_ net277 _1234_ _1125_ VGND VGND VPWR VPWR _1083_ sky130_fd_sc_hd__mux2_1
X_3686_ _1132_ _1153_ VGND VGND VPWR VPWR _1168_ sky130_fd_sc_hd__xor2_2
X_2706_ net291 net1108 _2023_ VGND VGND VPWR VPWR _0229_ sky130_fd_sc_hd__mux2_1
XPHY_EDGE_ROW_12_Right_12 VGND VGND VPWR VPWR sky130_fd_sc_hd__decap_3
X_2637_ net420 lsu.store_fifo.w_ptr\[0\] _2011_ VGND VGND VPWR VPWR _2013_ sky130_fd_sc_hd__nand3_2
X_2568_ lsu.current_load_addr\[11\] _1963_ net161 VGND VGND VPWR VPWR _0738_ sky130_fd_sc_hd__mux2_4
XFILLER_99_262 VGND VGND VPWR VPWR sky130_fd_sc_hd__fill_1
X_2499_ lsu.storer_state\[0\] _1445_ _1446_ _1714_ VGND VGND VPWR VPWR _1911_ sky130_fd_sc_hd__and4_1
X_4307_ clknet_leaf_2_clk _0364_ VGND VGND VPWR VPWR lsu.load_fifo.queue\[10\]\[13\]
+ sky130_fd_sc_hd__dfxtp_1
X_4238_ clknet_leaf_53_clk _0295_ VGND VGND VPWR VPWR lsu.store_fifo.queue\[3\]\[6\]
+ sky130_fd_sc_hd__dfxtp_1
XFILLER_59_159 VGND VGND VPWR VPWR sky130_fd_sc_hd__fill_1
X_4169_ clknet_leaf_27_clk _0226_ VGND VGND VPWR VPWR lsu.load_fifo.queue\[11\]\[29\]
+ sky130_fd_sc_hd__dfxtp_1
XPHY_EDGE_ROW_21_Right_21 VGND VGND VPWR VPWR sky130_fd_sc_hd__decap_3
XFILLER_90_27 VGND VGND VPWR VPWR sky130_fd_sc_hd__fill_1
XTAP_TAPCELL_ROW_21_463 VGND VPWR sky130_fd_sc_hd__tapvpwrvgnd_1
XFILLER_23_98 VGND VGND VPWR VPWR sky130_fd_sc_hd__decap_4
XPHY_EDGE_ROW_30_Right_30 VGND VGND VPWR VPWR sky130_fd_sc_hd__decap_3
XFILLER_99_69 VPWR VGND VPWR VGND sky130_ef_sc_hd__decap_12
XTAP_TAPCELL_ROW_94_1259 VGND VPWR sky130_fd_sc_hd__tapvpwrvgnd_1
XFILLER_2_111 VGND VGND VPWR VPWR sky130_fd_sc_hd__decap_6
XFILLER_78_468 VGND VGND VPWR VPWR sky130_fd_sc_hd__decap_8
XFILLER_19_502 VGND VGND VPWR VPWR sky130_fd_sc_hd__fill_2
Xclkbuf_leaf_85_clk clknet_3_0__leaf_clk VGND VGND VPWR VPWR clknet_leaf_85_clk sky130_fd_sc_hd__clkbuf_8
XFILLER_46_321 VGND VGND VPWR VPWR sky130_fd_sc_hd__fill_1
XFILLER_0_69 VPWR VGND VPWR VGND sky130_ef_sc_hd__decap_12
XTAP_TAPCELL_ROW_29_552 VGND VPWR sky130_fd_sc_hd__tapvpwrvgnd_1
XTAP_TAPCELL_ROW_57_861 VGND VPWR sky130_fd_sc_hd__tapvpwrvgnd_1
XFILLER_34_549 VGND VGND VPWR VPWR sky130_fd_sc_hd__fill_2
XTAP_TAPCELL_ROW_103_1366 VGND VPWR sky130_fd_sc_hd__tapvpwrvgnd_1
X_3540_ net438 VGND VGND VPWR VPWR _0104_ sky130_fd_sc_hd__inv_2
X_3471_ net437 VGND VGND VPWR VPWR _0035_ sky130_fd_sc_hd__inv_2
X_2422_ net268 _1857_ VGND VGND VPWR VPWR _1858_ sky130_fd_sc_hd__nand2_1
XFILLER_43_3 VPWR VGND VPWR VGND sky130_ef_sc_hd__decap_12
XFILLER_96_221 VPWR VGND VPWR VGND sky130_ef_sc_hd__decap_12
X_2353_ lsu.store_counter\[12\] _1591_ VGND VGND VPWR VPWR _1792_ sky130_fd_sc_hd__or2_1
XTAP_TAPCELL_ROW_71_1012 VGND VPWR sky130_fd_sc_hd__tapvpwrvgnd_1
XFILLER_96_265 VPWR VGND VPWR VGND sky130_ef_sc_hd__decap_12
X_2284_ _1744_ _1743_ lsu.store_counter\[18\] VGND VGND VPWR VPWR _0898_ sky130_fd_sc_hd__mux2_1
X_4023_ lsu.store_fifo.queue\[4\]\[8\] lsu.store_fifo.queue\[5\]\[8\] lsu.store_fifo.queue\[6\]\[8\]
+ lsu.store_fifo.queue\[7\]\[8\] net415 net409 VGND VGND VPWR VPWR _1462_ sky130_fd_sc_hd__mux4_1
Xclkbuf_leaf_76_clk clknet_3_1__leaf_clk VGND VGND VPWR VPWR clknet_leaf_76_clk sky130_fd_sc_hd__clkbuf_8
XFILLER_25_549 VGND VGND VPWR VPWR sky130_fd_sc_hd__fill_1
XTAP_TAPCELL_ROW_82_1130 VGND VPWR sky130_fd_sc_hd__tapvpwrvgnd_1
XFILLER_100_26 VGND VGND VPWR VPWR sky130_fd_sc_hd__fill_2
X_4925_ clknet_leaf_84_clk _0980_ VGND VGND VPWR VPWR lsu.load_fifo.queue\[13\]\[20\]
+ sky130_fd_sc_hd__dfxtp_1
X_4856_ clknet_leaf_40_clk _0911_ _0106_ VGND VGND VPWR VPWR lsu.load_counter\[6\]
+ sky130_fd_sc_hd__dfrtp_1
X_3807_ net1286 _1275_ net254 VGND VGND VPWR VPWR _1030_ sky130_fd_sc_hd__mux2_1
X_4787_ clknet_leaf_67_clk _0844_ VGND VGND VPWR VPWR lsu.store_fifo.queue\[0\]\[7\]
+ sky130_fd_sc_hd__dfxtp_1
X_3738_ _1206_ _1211_ VGND VGND VPWR VPWR _1220_ sky130_fd_sc_hd__nand2_1
XFILLER_106_337 VGND VGND VPWR VPWR sky130_fd_sc_hd__fill_2
Xclkload80 clknet_leaf_44_clk VGND VGND VPWR VPWR clkload80/X sky130_fd_sc_hd__clkbuf_8
X_3669_ _1136_ _1150_ VGND VGND VPWR VPWR _1151_ sky130_fd_sc_hd__nand2b_1
XFILLER_102_565 VGND VGND VPWR VPWR sky130_fd_sc_hd__fill_1
XFILLER_75_427 VPWR VGND VPWR VGND sky130_ef_sc_hd__decap_12
XFILLER_75_405 VPWR VGND VPWR VGND sky130_ef_sc_hd__decap_12
XFILLER_75_449 VPWR VGND VPWR VGND sky130_ef_sc_hd__decap_12
XFILLER_18_21 VGND VGND VPWR VPWR sky130_fd_sc_hd__fill_1
Xclkbuf_leaf_67_clk clknet_3_5__leaf_clk VGND VGND VPWR VPWR clknet_leaf_67_clk sky130_fd_sc_hd__clkbuf_8
XFILLER_55_151 VGND VGND VPWR VPWR sky130_fd_sc_hd__fill_1
XTAP_TAPCELL_ROW_26_511 VGND VPWR sky130_fd_sc_hd__tapvpwrvgnd_1
XFILLER_43_335 VGND VGND VPWR VPWR sky130_fd_sc_hd__fill_1
XTAP_TAPCELL_ROW_54_820 VGND VPWR sky130_fd_sc_hd__tapvpwrvgnd_1
XFILLER_24_560 VGND VGND VPWR VPWR sky130_fd_sc_hd__decap_6
XFILLER_51_390 VGND VGND VPWR VPWR sky130_fd_sc_hd__fill_2
XFILLER_50_41 VGND VGND VPWR VPWR sky130_fd_sc_hd__fill_1
XFILLER_50_85 VGND VGND VPWR VPWR sky130_fd_sc_hd__fill_1
XFILLER_3_497 VGND VGND VPWR VPWR sky130_fd_sc_hd__decap_6
XFILLER_59_83 VGND VGND VPWR VPWR sky130_fd_sc_hd__decap_6
XFILLER_66_427 VGND VGND VPWR VPWR sky130_fd_sc_hd__fill_1
XTAP_TAPCELL_ROW_6_291 VGND VPWR sky130_fd_sc_hd__tapvpwrvgnd_1
Xclkbuf_leaf_58_clk clknet_3_4__leaf_clk VGND VGND VPWR VPWR clknet_leaf_58_clk sky130_fd_sc_hd__clkbuf_8
XFILLER_93_279 VGND VGND VPWR VPWR sky130_fd_sc_hd__fill_1
X_2971_ _2038_ VGND VGND VPWR VPWR _2039_ sky130_fd_sc_hd__inv_2
X_4710_ clknet_leaf_28_clk _0767_ VGND VGND VPWR VPWR net115 sky130_fd_sc_hd__dfxtp_1
XFILLER_91_81 VPWR VGND VPWR VGND sky130_ef_sc_hd__decap_12
X_4641_ clknet_leaf_68_clk _0698_ VGND VGND VPWR VPWR lsu.load_fifo.queue\[15\]\[25\]
+ sky130_fd_sc_hd__dfxtp_1
XTAP_TAPCELL_ROW_60_889 VGND VPWR sky130_fd_sc_hd__tapvpwrvgnd_1
X_4572_ clknet_leaf_82_clk _0629_ VGND VGND VPWR VPWR lsu.load_fifo.queue\[0\]\[20\]
+ sky130_fd_sc_hd__dfxtp_1
Xhold715 lsu.load_fifo.queue\[14\]\[29\] VGND VGND VPWR VPWR net1183 sky130_fd_sc_hd__dlygate4sd3_1
X_3523_ net440 VGND VGND VPWR VPWR _0087_ sky130_fd_sc_hd__inv_2
Xhold737 lsu.load_fifo.queue\[1\]\[27\] VGND VGND VPWR VPWR net1205 sky130_fd_sc_hd__dlygate4sd3_1
Xhold726 lsu.load_fifo.queue\[9\]\[6\] VGND VGND VPWR VPWR net1194 sky130_fd_sc_hd__dlygate4sd3_1
Xhold704 lsu.load_fifo.queue\[9\]\[26\] VGND VGND VPWR VPWR net1172 sky130_fd_sc_hd__dlygate4sd3_1
X_3454_ net426 VGND VGND VPWR VPWR _0018_ sky130_fd_sc_hd__inv_2
Xhold759 lsu.load_fifo.queue\[15\]\[29\] VGND VGND VPWR VPWR net1227 sky130_fd_sc_hd__dlygate4sd3_1
Xhold748 lsu.load_fifo.queue\[13\]\[3\] VGND VGND VPWR VPWR net1216 sky130_fd_sc_hd__dlygate4sd3_1
X_2405_ _1110_ _1840_ VGND VGND VPWR VPWR _1841_ sky130_fd_sc_hd__nor2_1
X_3385_ net907 net352 net198 VGND VGND VPWR VPWR _1035_ sky130_fd_sc_hd__mux2_1
X_2336_ _1111_ lsu.load_fifo.w_ptr\[0\] _1257_ VGND VGND VPWR VPWR _1776_ sky130_fd_sc_hd__o21ai_1
X_2267_ lsu.store_counter\[15\] lsu.store_counter\[14\] _1731_ VGND VGND VPWR VPWR
+ _1732_ sky130_fd_sc_hd__and3_1
Xclkbuf_leaf_49_clk clknet_3_5__leaf_clk VGND VGND VPWR VPWR clknet_leaf_49_clk sky130_fd_sc_hd__clkbuf_8
XFILLER_57_449 VGND VGND VPWR VPWR sky130_fd_sc_hd__fill_2
XFILLER_72_419 VGND VGND VPWR VPWR sky130_fd_sc_hd__fill_1
XTAP_TAPCELL_ROW_68_978 VGND VPWR sky130_fd_sc_hd__tapvpwrvgnd_1
X_4006_ net414 lsu.store_fifo.w_ptr\[0\] VGND VGND VPWR VPWR _1446_ sky130_fd_sc_hd__xnor2_2
X_2198_ net167 net165 _1675_ net263 net245 VGND VGND VPWR VPWR _1684_ sky130_fd_sc_hd__o221a_1
XFILLER_25_335 VGND VGND VPWR VPWR sky130_fd_sc_hd__fill_1
X_4908_ clknet_leaf_87_clk _0963_ VGND VGND VPWR VPWR lsu.load_fifo.queue\[13\]\[3\]
+ sky130_fd_sc_hd__dfxtp_1
X_4839_ clknet_leaf_45_clk _0896_ _0089_ VGND VGND VPWR VPWR lsu.store_counter\[16\]
+ sky130_fd_sc_hd__dfrtp_1
XFILLER_21_585 VPWR VGND VPWR VGND sky130_ef_sc_hd__decap_12
XTAP_TAPCELL_ROW_91_1229 VGND VPWR sky130_fd_sc_hd__tapvpwrvgnd_1
XFILLER_20_55 VGND VGND VPWR VPWR sky130_fd_sc_hd__decap_3
XFILLER_96_15 VPWR VGND VPWR VGND sky130_ef_sc_hd__decap_12
XFILLER_0_445 VGND VGND VPWR VPWR sky130_fd_sc_hd__decap_3
XFILLER_88_563 VGND VGND VPWR VPWR sky130_fd_sc_hd__fill_1
Xhold31 acc.start VGND VGND VPWR VPWR net499 sky130_fd_sc_hd__dlygate4sd3_1
XFILLER_0_489 VPWR VGND VPWR VGND sky130_ef_sc_hd__decap_12
Xhold42 lsu.load_fifo.queue\[8\]\[2\] VGND VGND VPWR VPWR net510 sky130_fd_sc_hd__dlygate4sd3_1
Xhold64 lsu.load_fifo.queue\[4\]\[31\] VGND VGND VPWR VPWR net532 sky130_fd_sc_hd__dlygate4sd3_1
Xhold53 lsu.load_fifo.queue\[15\]\[12\] VGND VGND VPWR VPWR net521 sky130_fd_sc_hd__dlygate4sd3_1
Xhold97 net112 VGND VGND VPWR VPWR net565 sky130_fd_sc_hd__dlygate4sd3_1
XTAP_TAPCELL_ROW_3_261 VGND VPWR sky130_fd_sc_hd__tapvpwrvgnd_1
Xhold75 lsu.load_fifo.queue\[11\]\[19\] VGND VGND VPWR VPWR net543 sky130_fd_sc_hd__dlygate4sd3_1
Xhold86 lsu.store_fifo.queue\[12\]\[8\] VGND VGND VPWR VPWR net554 sky130_fd_sc_hd__dlygate4sd3_1
XFILLER_44_611 VGND VGND VPWR VPWR sky130_fd_sc_hd__fill_2
XFILLER_71_485 VPWR VGND VPWR VGND sky130_ef_sc_hd__decap_12
XTAP_TAPCELL_ROW_100_1325 VGND VPWR sky130_fd_sc_hd__tapvpwrvgnd_1
XFILLER_31_349 VGND VGND VPWR VPWR sky130_fd_sc_hd__decap_8
XFILLER_8_501 VPWR VGND VPWR VGND sky130_ef_sc_hd__decap_12
XFILLER_8_545 VPWR VGND VPWR VGND sky130_ef_sc_hd__decap_12
XFILLER_61_73 VGND VGND VPWR VPWR sky130_fd_sc_hd__fill_2
XFILLER_8_589 VPWR VGND VPWR VGND sky130_ef_sc_hd__decap_12
XANTENNA_6 lsu.current_load_addr\[8\] VGND VGND VPWR VPWR sky130_fd_sc_hd__diode_2
XFILLER_79_585 VPWR VGND VPWR VGND sky130_ef_sc_hd__decap_12
X_3170_ net743 net292 net178 VGND VGND VPWR VPWR _0672_ sky130_fd_sc_hd__mux2_1
X_2121_ _1602_ _1604_ _1607_ _1608_ VGND VGND VPWR VPWR _1611_ sky130_fd_sc_hd__or4b_1
XFILLER_39_438 VGND VGND VPWR VPWR sky130_fd_sc_hd__fill_1
XFILLER_39_449 VGND VGND VPWR VPWR sky130_fd_sc_hd__fill_2
XFILLER_54_419 VGND VGND VPWR VPWR sky130_fd_sc_hd__fill_1
XTAP_TAPCELL_ROW_37_639 VGND VPWR sky130_fd_sc_hd__tapvpwrvgnd_1
XTAP_TAPCELL_ROW_65_948 VGND VPWR sky130_fd_sc_hd__tapvpwrvgnd_1
X_2954_ net322 net887 net217 VGND VGND VPWR VPWR _0465_ sky130_fd_sc_hd__mux2_1
X_2885_ net1127 net328 net193 VGND VGND VPWR VPWR _0396_ sky130_fd_sc_hd__mux2_1
XPHY_EDGE_ROW_6_Right_6 VGND VGND VPWR VPWR sky130_fd_sc_hd__decap_3
X_4624_ clknet_leaf_33_clk _0681_ VGND VGND VPWR VPWR lsu.load_fifo.queue\[15\]\[8\]
+ sky130_fd_sc_hd__dfxtp_1
X_4555_ clknet_leaf_86_clk _0612_ VGND VGND VPWR VPWR lsu.load_fifo.queue\[0\]\[3\]
+ sky130_fd_sc_hd__dfxtp_1
Xhold501 lsu.load_fifo.queue\[13\]\[28\] VGND VGND VPWR VPWR net969 sky130_fd_sc_hd__dlygate4sd3_1
X_3506_ net444 VGND VGND VPWR VPWR _0070_ sky130_fd_sc_hd__inv_2
Xhold523 lsu.load_fifo.queue\[11\]\[24\] VGND VGND VPWR VPWR net991 sky130_fd_sc_hd__dlygate4sd3_1
XTAP_TAPCELL_ROW_77_1073 VGND VPWR sky130_fd_sc_hd__tapvpwrvgnd_1
Xhold545 lsu.load_fifo.queue\[4\]\[21\] VGND VGND VPWR VPWR net1013 sky130_fd_sc_hd__dlygate4sd3_1
Xhold534 lsu.load_fifo.queue\[1\]\[0\] VGND VGND VPWR VPWR net1002 sky130_fd_sc_hd__dlygate4sd3_1
Xhold512 lsu.load_fifo.queue\[15\]\[31\] VGND VGND VPWR VPWR net980 sky130_fd_sc_hd__dlygate4sd3_1
XFILLER_89_305 VPWR VGND VPWR VGND sky130_ef_sc_hd__decap_12
Xhold578 lsu.load_fifo.queue\[10\]\[6\] VGND VGND VPWR VPWR net1046 sky130_fd_sc_hd__dlygate4sd3_1
Xhold556 lsu.store_fifo.queue\[11\]\[4\] VGND VGND VPWR VPWR net1024 sky130_fd_sc_hd__dlygate4sd3_1
X_4486_ clknet_leaf_12_clk _0543_ VGND VGND VPWR VPWR lsu.load_fifo.queue\[3\]\[30\]
+ sky130_fd_sc_hd__dfxtp_1
Xhold567 lsu.store_fifo.queue\[5\]\[6\] VGND VGND VPWR VPWR net1035 sky130_fd_sc_hd__dlygate4sd3_1
X_3437_ net809 net273 _2059_ VGND VGND VPWR VPWR _1095_ sky130_fd_sc_hd__mux2_1
Xhold589 lsu.store_fifo.queue\[9\]\[6\] VGND VGND VPWR VPWR net1057 sky130_fd_sc_hd__dlygate4sd3_1
X_3368_ net320 net834 net170 VGND VGND VPWR VPWR _0977_ sky130_fd_sc_hd__mux2_1
XFILLER_66_18 VGND VGND VPWR VPWR sky130_fd_sc_hd__decap_8
X_2319_ _1726_ _1764_ _1765_ lsu.store_counter\[4\] VGND VGND VPWR VPWR _0884_ sky130_fd_sc_hd__a22o_1
X_3299_ net326 net52 net248 VGND VGND VPWR VPWR _0861_ sky130_fd_sc_hd__mux2_1
XTAP_TAPCELL_ROW_0_220 VGND VPWR sky130_fd_sc_hd__tapvpwrvgnd_1
X_5038_ clknet_leaf_63_clk _1093_ VGND VGND VPWR VPWR lsu.store_fifo.queue\[12\]\[7\]
+ sky130_fd_sc_hd__dfxtp_1
XFILLER_72_249 VGND VGND VPWR VPWR sky130_fd_sc_hd__decap_3
XTAP_TAPCELL_ROW_0_231 VGND VPWR sky130_fd_sc_hd__tapvpwrvgnd_1
XFILLER_65_290 VGND VGND VPWR VPWR sky130_fd_sc_hd__decap_6
XFILLER_25_165 VGND VGND VPWR VPWR sky130_fd_sc_hd__decap_3
XFILLER_80_282 VGND VGND VPWR VPWR sky130_fd_sc_hd__fill_2
XFILLER_15_55 VGND VGND VPWR VPWR sky130_fd_sc_hd__fill_1
XFILLER_15_99 VGND VGND VPWR VPWR sky130_fd_sc_hd__decap_4
XFILLER_21_393 VGND VGND VPWR VPWR sky130_fd_sc_hd__decap_6
XFILLER_5_559 VGND VGND VPWR VPWR sky130_fd_sc_hd__fill_1
XTAP_TAPCELL_ROW_8_320 VGND VPWR sky130_fd_sc_hd__tapvpwrvgnd_1
XFILLER_0_253 VGND VGND VPWR VPWR sky130_fd_sc_hd__decap_8
XFILLER_48_213 VGND VGND VPWR VPWR sky130_fd_sc_hd__fill_1
XFILLER_91_503 VGND VGND VPWR VPWR sky130_fd_sc_hd__fill_1
XFILLER_91_514 VGND VGND VPWR VPWR sky130_fd_sc_hd__decap_6
XFILLER_91_569 VPWR VGND VPWR VGND sky130_ef_sc_hd__decap_12
XTAP_TAPCELL_ROW_62_907 VGND VPWR sky130_fd_sc_hd__tapvpwrvgnd_1
XFILLER_16_165 VGND VGND VPWR VPWR sky130_fd_sc_hd__fill_1
XTAP_TAPCELL_ROW_34_609 VGND VPWR sky130_fd_sc_hd__tapvpwrvgnd_1
XFILLER_16_187 VGND VGND VPWR VPWR sky130_fd_sc_hd__fill_1
XFILLER_44_485 VPWR VGND VPWR VGND sky130_ef_sc_hd__decap_12
XTAP_TAPCELL_ROW_70_995 VGND VPWR sky130_fd_sc_hd__tapvpwrvgnd_1
XTAP_TAPCELL_ROW_14_388 VGND VPWR sky130_fd_sc_hd__tapvpwrvgnd_1
XFILLER_12_382 VPWR VGND VPWR VGND sky130_ef_sc_hd__decap_12
XTAP_TAPCELL_ROW_42_697 VGND VPWR sky130_fd_sc_hd__tapvpwrvgnd_1
XPHY_EDGE_ROW_59_Right_59 VGND VGND VPWR VPWR sky130_fd_sc_hd__decap_3
X_2670_ net660 net274 _2021_ VGND VGND VPWR VPWR _0195_ sky130_fd_sc_hd__mux2_1
X_4340_ clknet_leaf_3_clk _0397_ VGND VGND VPWR VPWR lsu.load_fifo.queue\[7\]\[14\]
+ sky130_fd_sc_hd__dfxtp_1
XFILLER_4_581 VGND VGND VPWR VPWR sky130_fd_sc_hd__decap_6
X_4271_ clknet_leaf_78_clk _0328_ VGND VGND VPWR VPWR lsu.load_fifo.queue\[9\]\[9\]
+ sky130_fd_sc_hd__dfxtp_1
X_3222_ net501 net280 _2050_ VGND VGND VPWR VPWR _0758_ sky130_fd_sc_hd__mux2_1
XFILLER_79_393 VGND VGND VPWR VPWR sky130_fd_sc_hd__decap_6
XPHY_EDGE_ROW_68_Right_68 VGND VGND VPWR VPWR sky130_fd_sc_hd__decap_3
X_3153_ net1129 net327 net177 VGND VGND VPWR VPWR _0655_ sky130_fd_sc_hd__mux2_1
X_2104_ _1562_ _1593_ VGND VGND VPWR VPWR _1594_ sky130_fd_sc_hd__and2_1
XFILLER_67_555 VGND VGND VPWR VPWR sky130_fd_sc_hd__decap_4
XFILLER_82_514 VPWR VGND VPWR VGND sky130_ef_sc_hd__decap_12
X_3084_ net332 net917 net185 VGND VGND VPWR VPWR _0588_ sky130_fd_sc_hd__mux2_1
XFILLER_23_614 VGND VGND VPWR VPWR sky130_fd_sc_hd__fill_2
XPHY_EDGE_ROW_77_Right_77 VGND VGND VPWR VPWR sky130_fd_sc_hd__decap_3
X_3986_ _1426_ _1428_ _1425_ _1427_ net358 net364 VGND VGND VPWR VPWR _1429_ sky130_fd_sc_hd__mux4_1
X_2937_ net416 lsu.load_fifo.w_ptr\[1\] _1997_ net419 VGND VGND VPWR VPWR _2037_ sky130_fd_sc_hd__or4b_4
XFILLER_50_477 VPWR VGND VPWR VGND sky130_ef_sc_hd__decap_12
XTAP_TAPCELL_ROW_79_1102 VGND VPWR sky130_fd_sc_hd__tapvpwrvgnd_1
X_4607_ clknet_leaf_80_clk _0664_ VGND VGND VPWR VPWR lsu.load_fifo.queue\[8\]\[23\]
+ sky130_fd_sc_hd__dfxtp_1
X_2868_ net512 net299 net224 VGND VGND VPWR VPWR _0379_ sky130_fd_sc_hd__mux2_1
Xhold320 lsu.load_fifo.queue\[12\]\[20\] VGND VGND VPWR VPWR net788 sky130_fd_sc_hd__dlygate4sd3_1
X_2799_ net282 net993 _2032_ VGND VGND VPWR VPWR _0313_ sky130_fd_sc_hd__mux2_1
Xhold331 net113 VGND VGND VPWR VPWR net799 sky130_fd_sc_hd__dlygate4sd3_1
XFILLER_89_113 VGND VGND VPWR VPWR sky130_fd_sc_hd__fill_2
Xhold353 lsu.load_fifo.queue\[8\]\[25\] VGND VGND VPWR VPWR net821 sky130_fd_sc_hd__dlygate4sd3_1
Xhold342 lsu.load_fifo.queue\[4\]\[11\] VGND VGND VPWR VPWR net810 sky130_fd_sc_hd__dlygate4sd3_1
X_4538_ clknet_leaf_8_clk _0595_ VGND VGND VPWR VPWR lsu.load_fifo.queue\[1\]\[18\]
+ sky130_fd_sc_hd__dfxtp_1
Xhold386 net119 VGND VGND VPWR VPWR net854 sky130_fd_sc_hd__dlygate4sd3_1
Xhold364 lsu.load_fifo.queue\[15\]\[1\] VGND VGND VPWR VPWR net832 sky130_fd_sc_hd__dlygate4sd3_1
X_4469_ clknet_leaf_4_clk _0526_ VGND VGND VPWR VPWR lsu.load_fifo.queue\[3\]\[13\]
+ sky130_fd_sc_hd__dfxtp_1
Xhold375 lsu.load_fifo.queue\[14\]\[19\] VGND VGND VPWR VPWR net843 sky130_fd_sc_hd__dlygate4sd3_1
XPHY_EDGE_ROW_86_Right_86 VGND VGND VPWR VPWR sky130_fd_sc_hd__decap_3
Xhold397 lsu.load_fifo.queue\[12\]\[1\] VGND VGND VPWR VPWR net865 sky130_fd_sc_hd__dlygate4sd3_1
XFILLER_93_27 VPWR VGND VPWR VGND sky130_ef_sc_hd__decap_12
XFILLER_85_385 VGND VGND VPWR VPWR sky130_fd_sc_hd__fill_1
XFILLER_73_503 VGND VGND VPWR VPWR sky130_fd_sc_hd__fill_1
XFILLER_26_430 VGND VGND VPWR VPWR sky130_fd_sc_hd__fill_1
XPHY_EDGE_ROW_95_Right_95 VGND VGND VPWR VPWR sky130_fd_sc_hd__decap_3
XFILLER_81_591 VGND VGND VPWR VPWR sky130_fd_sc_hd__fill_2
XFILLER_14_625 VGND VGND VPWR VPWR sky130_fd_sc_hd__decap_4
XFILLER_13_102 VGND VGND VPWR VPWR sky130_fd_sc_hd__fill_1
XFILLER_13_146 VGND VGND VPWR VPWR sky130_fd_sc_hd__decap_4
XTAP_TAPCELL_ROW_11_347 VGND VPWR sky130_fd_sc_hd__tapvpwrvgnd_1
XFILLER_95_105 VGND VGND VPWR VPWR sky130_fd_sc_hd__decap_6
XFILLER_1_573 VPWR VGND VPWR VGND sky130_ef_sc_hd__decap_12
XFILLER_3_69 VPWR VGND VPWR VGND sky130_ef_sc_hd__decap_12
XFILLER_91_322 VPWR VGND VPWR VGND sky130_ef_sc_hd__decap_12
XTAP_TAPCELL_ROW_19_436 VGND VPWR sky130_fd_sc_hd__tapvpwrvgnd_1
XTAP_TAPCELL_ROW_47_745 VGND VPWR sky130_fd_sc_hd__tapvpwrvgnd_1
XFILLER_91_377 VGND VGND VPWR VPWR sky130_fd_sc_hd__fill_1
XFILLER_17_441 VGND VGND VPWR VPWR sky130_fd_sc_hd__decap_6
XFILLER_91_399 VGND VGND VPWR VPWR sky130_fd_sc_hd__decap_6
XFILLER_17_485 VPWR VGND VPWR VGND sky130_ef_sc_hd__decap_12
XFILLER_44_271 VGND VGND VPWR VPWR sky130_fd_sc_hd__fill_1
XTAP_TAPCELL_ROW_106_1397 VGND VPWR sky130_fd_sc_hd__tapvpwrvgnd_1
X_3840_ lsu.load_fifo.queue\[0\]\[23\] lsu.load_fifo.queue\[1\]\[23\] lsu.load_fifo.queue\[2\]\[23\]
+ lsu.load_fifo.queue\[3\]\[23\] net388 net371 VGND VGND VPWR VPWR _1304_ sky130_fd_sc_hd__mux4_1
XFILLER_32_466 VGND VGND VPWR VPWR sky130_fd_sc_hd__decap_8
XFILLER_32_488 VPWR VGND VPWR VGND sky130_ef_sc_hd__decap_12
X_3771_ _1143_ _1217_ _1216_ VGND VGND VPWR VPWR _1244_ sky130_fd_sc_hd__o21a_1
Xlsu_wrapper_450 VGND VGND VPWR VPWR lsu_wrapper_450/HI store_data[13] sky130_fd_sc_hd__conb_1
X_2722_ net507 net283 _2025_ VGND VGND VPWR VPWR _0243_ sky130_fd_sc_hd__mux2_1
XFILLER_73_3 VGND VGND VPWR VPWR sky130_fd_sc_hd__fill_1
Xlsu_wrapper_461 VGND VGND VPWR VPWR lsu_wrapper_461/HI store_data[24] sky130_fd_sc_hd__conb_1
X_2653_ net284 net955 _2019_ VGND VGND VPWR VPWR _0180_ sky130_fd_sc_hd__mux2_1
X_2584_ lsu.current_load_addr\[5\] lsu.current_load_addr\[4\] _1921_ lsu.current_load_addr\[6\]
+ VGND VGND VPWR VPWR _1975_ sky130_fd_sc_hd__a31o_1
XFILLER_99_444 VGND VGND VPWR VPWR sky130_fd_sc_hd__decap_4
X_4323_ clknet_leaf_27_clk _0380_ VGND VGND VPWR VPWR lsu.load_fifo.queue\[10\]\[29\]
+ sky130_fd_sc_hd__dfxtp_1
XTAP_TAPCELL_ROW_74_1043 VGND VPWR sky130_fd_sc_hd__tapvpwrvgnd_1
X_4254_ clknet_leaf_57_clk _0311_ VGND VGND VPWR VPWR lsu.store_fifo.queue\[1\]\[2\]
+ sky130_fd_sc_hd__dfxtp_1
XFILLER_101_449 VPWR VGND VPWR VGND sky130_ef_sc_hd__decap_12
X_4185_ clknet_leaf_67_clk _0242_ VGND VGND VPWR VPWR lsu.store_fifo.queue\[8\]\[3\]
+ sky130_fd_sc_hd__dfxtp_1
X_3205_ _2013_ _2048_ VGND VGND VPWR VPWR _2049_ sky130_fd_sc_hd__or2_4
XFILLER_103_15 VPWR VGND VPWR VGND sky130_ef_sc_hd__decap_12
XFILLER_55_503 VGND VGND VPWR VPWR sky130_fd_sc_hd__fill_1
X_3136_ net912 net295 net183 VGND VGND VPWR VPWR _0639_ sky130_fd_sc_hd__mux2_1
X_3067_ net796 net300 net207 VGND VGND VPWR VPWR _0572_ sky130_fd_sc_hd__mux2_1
XTAP_TAPCELL_ROW_85_1161 VGND VPWR sky130_fd_sc_hd__tapvpwrvgnd_1
XFILLER_82_388 VGND VGND VPWR VPWR sky130_fd_sc_hd__fill_1
XFILLER_11_617 VPWR VGND VPWR VGND sky130_ef_sc_hd__decap_12
X_3969_ lsu.load_fifo.queue\[0\]\[4\] lsu.load_fifo.queue\[1\]\[4\] lsu.load_fifo.queue\[2\]\[4\]
+ lsu.load_fifo.queue\[3\]\[4\] net391 net374 VGND VGND VPWR VPWR _1414_ sky130_fd_sc_hd__mux4_1
XFILLER_88_27 VGND VGND VPWR VPWR sky130_fd_sc_hd__fill_1
XTAP_TAPCELL_ROW_96_1290 VGND VPWR sky130_fd_sc_hd__tapvpwrvgnd_1
Xhold161 lsu.load_fifo.queue\[8\]\[29\] VGND VGND VPWR VPWR net629 sky130_fd_sc_hd__dlygate4sd3_1
Xhold150 lsu.load_fifo.queue\[8\]\[28\] VGND VGND VPWR VPWR net618 sky130_fd_sc_hd__dlygate4sd3_1
Xhold172 lsu.load_fifo.queue\[12\]\[0\] VGND VGND VPWR VPWR net640 sky130_fd_sc_hd__dlygate4sd3_1
Xhold183 lsu.load_fifo.queue\[7\]\[1\] VGND VGND VPWR VPWR net651 sky130_fd_sc_hd__dlygate4sd3_1
Xhold194 lsu.store_fifo.queue\[14\]\[2\] VGND VGND VPWR VPWR net662 sky130_fd_sc_hd__dlygate4sd3_1
XFILLER_104_298 VGND VGND VPWR VPWR sky130_fd_sc_hd__decap_6
XFILLER_100_460 VGND VGND VPWR VPWR sky130_fd_sc_hd__decap_4
XFILLER_100_471 VGND VGND VPWR VPWR sky130_fd_sc_hd__decap_4
XFILLER_58_363 VGND VGND VPWR VPWR sky130_fd_sc_hd__fill_1
XFILLER_58_374 VGND VGND VPWR VPWR sky130_fd_sc_hd__decap_4
XFILLER_18_227 VGND VGND VPWR VPWR sky130_fd_sc_hd__decap_6
XTAP_TAPCELL_ROW_16_406 VGND VPWR sky130_fd_sc_hd__tapvpwrvgnd_1
XFILLER_33_219 VGND VGND VPWR VPWR sky130_fd_sc_hd__decap_4
XTAP_TAPCELL_ROW_44_715 VGND VPWR sky130_fd_sc_hd__tapvpwrvgnd_1
XFILLER_14_433 VPWR VGND VPWR VGND sky130_ef_sc_hd__decap_12
XFILLER_14_477 VPWR VGND VPWR VGND sky130_ef_sc_hd__decap_12
XFILLER_41_263 VGND VGND VPWR VPWR sky130_fd_sc_hd__decap_4
XTAP_TAPCELL_ROW_99_1319 VGND VPWR sky130_fd_sc_hd__tapvpwrvgnd_1
XTAP_TAPCELL_ROW_24_494 VGND VPWR sky130_fd_sc_hd__tapvpwrvgnd_1
XFILLER_5_186 VGND VGND VPWR VPWR sky130_fd_sc_hd__decap_4
XFILLER_78_60 VGND VGND VPWR VPWR sky130_fd_sc_hd__fill_1
XFILLER_49_341 VGND VGND VPWR VPWR sky130_fd_sc_hd__decap_3
XFILLER_37_514 VGND VGND VPWR VPWR sky130_fd_sc_hd__decap_4
X_4941_ clknet_leaf_62_clk _0996_ _0127_ VGND VGND VPWR VPWR net153 sky130_fd_sc_hd__dfrtp_1
X_4872_ clknet_leaf_42_clk _0927_ _0122_ VGND VGND VPWR VPWR lsu.load_counter\[22\]
+ sky130_fd_sc_hd__dfrtp_1
X_3823_ lsu.load_fifo.queue\[0\]\[25\] lsu.load_fifo.queue\[1\]\[25\] lsu.load_fifo.queue\[2\]\[25\]
+ lsu.load_fifo.queue\[3\]\[25\] net388 net371 VGND VGND VPWR VPWR _1289_ sky130_fd_sc_hd__mux4_1
XFILLER_20_469 VGND VGND VPWR VPWR sky130_fd_sc_hd__decap_6
X_3754_ _1171_ _1230_ VGND VGND VPWR VPWR _1234_ sky130_fd_sc_hd__xor2_1
X_3685_ _1165_ _1166_ VGND VGND VPWR VPWR _1167_ sky130_fd_sc_hd__nand2_1
X_2705_ net420 _2012_ _2016_ VGND VGND VPWR VPWR _2023_ sky130_fd_sc_hd__or3_4
X_2636_ lsu.store_fifo.w_ptr\[0\] _2011_ VGND VGND VPWR VPWR _2012_ sky130_fd_sc_hd__nand2_2
X_2567_ net26 net259 _1961_ _1962_ VGND VGND VPWR VPWR _1963_ sky130_fd_sc_hd__a22o_1
X_2498_ lsu.storer_state\[0\] _1714_ _1715_ lsu.storer_state\[1\] VGND VGND VPWR VPWR
+ _1910_ sky130_fd_sc_hd__a22oi_1
X_4306_ clknet_leaf_20_clk _0363_ VGND VGND VPWR VPWR lsu.load_fifo.queue\[10\]\[12\]
+ sky130_fd_sc_hd__dfxtp_1
X_4237_ clknet_leaf_58_clk _0294_ VGND VGND VPWR VPWR lsu.store_fifo.queue\[3\]\[5\]
+ sky130_fd_sc_hd__dfxtp_1
X_4168_ clknet_leaf_16_clk _0225_ VGND VGND VPWR VPWR lsu.load_fifo.queue\[11\]\[28\]
+ sky130_fd_sc_hd__dfxtp_1
X_4099_ net270 _1530_ VGND VGND VPWR VPWR _1531_ sky130_fd_sc_hd__nor2_1
X_3119_ net728 net329 net181 VGND VGND VPWR VPWR _0622_ sky130_fd_sc_hd__mux2_1
XFILLER_82_185 VGND VGND VPWR VPWR sky130_fd_sc_hd__fill_2
XFILLER_70_314 VGND VGND VPWR VPWR sky130_fd_sc_hd__fill_1
XFILLER_55_399 VGND VGND VPWR VPWR sky130_fd_sc_hd__fill_1
XFILLER_51_550 VGND VGND VPWR VPWR sky130_fd_sc_hd__decap_4
XFILLER_51_561 VPWR VGND VPWR VGND sky130_ef_sc_hd__decap_12
XFILLER_11_447 VGND VGND VPWR VPWR sky130_fd_sc_hd__fill_1
XFILLER_23_77 VGND VGND VPWR VPWR sky130_fd_sc_hd__fill_1
XTAP_TAPCELL_ROW_21_464 VGND VPWR sky130_fd_sc_hd__tapvpwrvgnd_1
XFILLER_3_3 VPWR VGND VPWR VGND sky130_ef_sc_hd__decap_12
XFILLER_93_406 VPWR VGND VPWR VGND sky130_ef_sc_hd__decap_12
XFILLER_48_85 VGND VGND VPWR VPWR sky130_fd_sc_hd__decap_6
XFILLER_65_108 VGND VGND VPWR VPWR sky130_fd_sc_hd__decap_4
XFILLER_0_15 VPWR VGND VPWR VGND sky130_ef_sc_hd__decap_12
XFILLER_19_569 VPWR VGND VPWR VGND sky130_ef_sc_hd__decap_12
XTAP_TAPCELL_ROW_29_553 VGND VPWR sky130_fd_sc_hd__tapvpwrvgnd_1
XTAP_TAPCELL_ROW_57_862 VGND VPWR sky130_fd_sc_hd__tapvpwrvgnd_1
XTAP_TAPCELL_ROW_103_1367 VGND VPWR sky130_fd_sc_hd__tapvpwrvgnd_1
XFILLER_9_57 VGND VGND VPWR VPWR sky130_fd_sc_hd__decap_6
X_3470_ net428 VGND VGND VPWR VPWR _0034_ sky130_fd_sc_hd__inv_2
X_2421_ lsu.current_store_addr\[21\] _1856_ VGND VGND VPWR VPWR _1857_ sky130_fd_sc_hd__xnor2_1
XFILLER_89_81 VPWR VGND VPWR VGND sky130_ef_sc_hd__decap_12
X_2352_ lsu.store_counter\[13\] _1594_ _1789_ _1790_ VGND VGND VPWR VPWR _1791_ sky130_fd_sc_hd__a211o_1
XTAP_TAPCELL_ROW_71_1013 VGND VPWR sky130_fd_sc_hd__tapvpwrvgnd_1
XFILLER_96_233 VPWR VGND VPWR VGND sky130_ef_sc_hd__decap_12
X_2283_ _1720_ _1733_ VGND VGND VPWR VPWR _1744_ sky130_fd_sc_hd__and2_1
XFILLER_96_277 VPWR VGND VPWR VGND sky130_ef_sc_hd__decap_12
X_4022_ net271 _1460_ VGND VGND VPWR VPWR _1461_ sky130_fd_sc_hd__nor2_1
XFILLER_64_185 VGND VGND VPWR VPWR sky130_fd_sc_hd__decap_8
XTAP_TAPCELL_ROW_82_1131 VGND VPWR sky130_fd_sc_hd__tapvpwrvgnd_1
X_4924_ clknet_leaf_8_clk _0979_ VGND VGND VPWR VPWR lsu.load_fifo.queue\[13\]\[19\]
+ sky130_fd_sc_hd__dfxtp_1
XFILLER_33_561 VGND VGND VPWR VPWR sky130_fd_sc_hd__fill_1
X_4855_ clknet_leaf_40_clk _0910_ _0105_ VGND VGND VPWR VPWR lsu.load_counter\[5\]
+ sky130_fd_sc_hd__dfrtp_1
X_4786_ clknet_leaf_50_clk _0843_ VGND VGND VPWR VPWR lsu.store_fifo.queue\[0\]\[6\]
+ sky130_fd_sc_hd__dfxtp_1
X_3806_ _1272_ _1274_ _1271_ _1273_ net358 net364 VGND VGND VPWR VPWR _1275_ sky130_fd_sc_hd__mux4_1
X_3737_ _1214_ _1218_ _1213_ VGND VGND VPWR VPWR _1219_ sky130_fd_sc_hd__a21oi_1
XFILLER_106_349 VGND VGND VPWR VPWR sky130_fd_sc_hd__decap_4
Xclkload70 clknet_leaf_37_clk VGND VGND VPWR VPWR clkload70/Y sky130_fd_sc_hd__clkinvlp_4
X_3668_ acc.byte1\[4\] acc.byte0\[4\] VGND VGND VPWR VPWR _1150_ sky130_fd_sc_hd__or2_1
X_2619_ net418 _1998_ VGND VGND VPWR VPWR _1999_ sky130_fd_sc_hd__nand2_1
Xclkload81 clknet_leaf_45_clk VGND VGND VPWR VPWR clkload81/X sky130_fd_sc_hd__clkbuf_4
X_3599_ net425 VGND VGND VPWR VPWR _0163_ sky130_fd_sc_hd__inv_2
XFILLER_102_577 VGND VGND VPWR VPWR sky130_fd_sc_hd__decap_8
XFILLER_87_277 VGND VGND VPWR VPWR sky130_fd_sc_hd__decap_3
XFILLER_75_417 VGND VGND VPWR VPWR sky130_fd_sc_hd__decap_6
XFILLER_75_439 VGND VGND VPWR VPWR sky130_fd_sc_hd__decap_8
XFILLER_83_461 VGND VGND VPWR VPWR sky130_fd_sc_hd__decap_3
XTAP_TAPCELL_ROW_26_512 VGND VPWR sky130_fd_sc_hd__tapvpwrvgnd_1
XFILLER_43_314 VGND VGND VPWR VPWR sky130_fd_sc_hd__decap_8
XTAP_TAPCELL_ROW_54_821 VGND VPWR sky130_fd_sc_hd__tapvpwrvgnd_1
XFILLER_43_369 VGND VGND VPWR VPWR sky130_fd_sc_hd__fill_1
XFILLER_78_233 VGND VGND VPWR VPWR sky130_fd_sc_hd__decap_3
XFILLER_93_225 VPWR VGND VPWR VGND sky130_ef_sc_hd__decap_12
XTAP_TAPCELL_ROW_6_292 VGND VPWR sky130_fd_sc_hd__tapvpwrvgnd_1
Xfanout290 acc.data_out\[0\] VGND VGND VPWR VPWR net290 sky130_fd_sc_hd__buf_2
XFILLER_46_141 VGND VGND VPWR VPWR sky130_fd_sc_hd__decap_6
XFILLER_61_111 VGND VGND VPWR VPWR sky130_fd_sc_hd__fill_1
X_2970_ lsu.load_fifo.w_ptr\[1\] lsu.load_fifo.w_ptr\[0\] _1996_ VGND VGND VPWR VPWR
+ _2038_ sky130_fd_sc_hd__or3b_1
XFILLER_15_561 VPWR VGND VPWR VGND sky130_ef_sc_hd__decap_12
XFILLER_91_93 VPWR VGND VPWR VGND sky130_ef_sc_hd__decap_12
X_4640_ clknet_leaf_30_clk _0697_ VGND VGND VPWR VPWR lsu.load_fifo.queue\[15\]\[24\]
+ sky130_fd_sc_hd__dfxtp_1
X_4571_ clknet_leaf_8_clk _0628_ VGND VGND VPWR VPWR lsu.load_fifo.queue\[0\]\[19\]
+ sky130_fd_sc_hd__dfxtp_1
X_3522_ net440 VGND VGND VPWR VPWR _0086_ sky130_fd_sc_hd__inv_2
Xhold727 lsu.load_fifo.queue\[15\]\[17\] VGND VGND VPWR VPWR net1195 sky130_fd_sc_hd__dlygate4sd3_1
Xhold716 lsu.load_fifo.queue\[6\]\[22\] VGND VGND VPWR VPWR net1184 sky130_fd_sc_hd__dlygate4sd3_1
Xhold705 lsu.store_fifo.queue\[15\]\[4\] VGND VGND VPWR VPWR net1173 sky130_fd_sc_hd__dlygate4sd3_1
X_3453_ net426 VGND VGND VPWR VPWR _0017_ sky130_fd_sc_hd__inv_2
Xhold749 lsu.load_fifo.queue\[13\]\[23\] VGND VGND VPWR VPWR net1217 sky130_fd_sc_hd__dlygate4sd3_1
Xhold738 lsu.load_fifo.queue\[13\]\[25\] VGND VGND VPWR VPWR net1206 sky130_fd_sc_hd__dlygate4sd3_1
X_2404_ lsu.current_store_addr\[1\] lsu.current_store_addr\[0\] VGND VGND VPWR VPWR
+ _1840_ sky130_fd_sc_hd__nand2_1
X_3384_ net758 net354 net201 VGND VGND VPWR VPWR _1034_ sky130_fd_sc_hd__mux2_1
X_2335_ lsu.load_fifo.w_ptr\[0\] _1257_ _1773_ _1774_ _1256_ VGND VGND VPWR VPWR _1775_
+ sky130_fd_sc_hd__o2111a_1
X_2266_ lsu.store_counter\[13\] lsu.store_counter\[12\] _1730_ VGND VGND VPWR VPWR
+ _1731_ sky130_fd_sc_hd__and3_1
X_2197_ lsu.load_counter\[19\] _1683_ _1681_ VGND VGND VPWR VPWR _0924_ sky130_fd_sc_hd__o21ba_1
XFILLER_84_269 VGND VGND VPWR VPWR sky130_fd_sc_hd__fill_1
XTAP_TAPCELL_ROW_68_979 VGND VPWR sky130_fd_sc_hd__tapvpwrvgnd_1
X_4005_ _1442_ _1443_ _1444_ VGND VGND VPWR VPWR _1445_ sky130_fd_sc_hd__and3_1
XFILLER_37_185 VGND VGND VPWR VPWR sky130_fd_sc_hd__decap_3
XFILLER_52_177 VGND VGND VPWR VPWR sky130_fd_sc_hd__decap_3
X_4907_ clknet_leaf_20_clk _0962_ VGND VGND VPWR VPWR lsu.load_fifo.queue\[13\]\[2\]
+ sky130_fd_sc_hd__dfxtp_1
X_4838_ clknet_leaf_45_clk _0895_ _0088_ VGND VGND VPWR VPWR lsu.store_counter\[15\]
+ sky130_fd_sc_hd__dfrtp_1
XFILLER_21_553 VGND VGND VPWR VPWR sky130_fd_sc_hd__decap_6
XFILLER_21_597 VPWR VGND VPWR VGND sky130_ef_sc_hd__decap_12
XTAP_TAPCELL_ROW_31_570 VGND VPWR sky130_fd_sc_hd__tapvpwrvgnd_1
X_4769_ clknet_leaf_48_clk net898 VGND VGND VPWR VPWR net133 sky130_fd_sc_hd__dfxtp_1
XFILLER_106_113 VGND VGND VPWR VPWR sky130_fd_sc_hd__fill_2
XFILLER_106_102 VGND VGND VPWR VPWR sky130_fd_sc_hd__fill_1
XFILLER_105_6 VPWR VGND VPWR VGND sky130_ef_sc_hd__decap_12
XFILLER_96_27 VGND VGND VPWR VPWR sky130_fd_sc_hd__fill_1
XFILLER_88_553 VGND VGND VPWR VPWR sky130_fd_sc_hd__fill_1
XFILLER_88_531 VGND VGND VPWR VPWR sky130_fd_sc_hd__fill_1
Xhold32 acc.state VGND VGND VPWR VPWR net500 sky130_fd_sc_hd__dlygate4sd3_1
Xhold65 net106 VGND VGND VPWR VPWR net533 sky130_fd_sc_hd__dlygate4sd3_1
XFILLER_75_225 VGND VGND VPWR VPWR sky130_fd_sc_hd__decap_3
XFILLER_48_439 VGND VGND VPWR VPWR sky130_fd_sc_hd__fill_2
Xhold43 lsu.load_fifo.queue\[11\]\[28\] VGND VGND VPWR VPWR net511 sky130_fd_sc_hd__dlygate4sd3_1
Xhold54 lsu.load_fifo.queue\[7\]\[12\] VGND VGND VPWR VPWR net522 sky130_fd_sc_hd__dlygate4sd3_1
Xhold76 lsu.load_fifo.queue\[15\]\[10\] VGND VGND VPWR VPWR net544 sky130_fd_sc_hd__dlygate4sd3_1
XTAP_TAPCELL_ROW_3_262 VGND VPWR sky130_fd_sc_hd__tapvpwrvgnd_1
XFILLER_28_141 VGND VGND VPWR VPWR sky130_fd_sc_hd__decap_6
Xhold87 lsu.store_fifo.queue\[14\]\[1\] VGND VGND VPWR VPWR net555 sky130_fd_sc_hd__dlygate4sd3_1
Xhold98 lsu.store_fifo.queue\[14\]\[4\] VGND VGND VPWR VPWR net566 sky130_fd_sc_hd__dlygate4sd3_1
XFILLER_90_228 VPWR VGND VPWR VGND sky130_ef_sc_hd__decap_12
XFILLER_16_347 VGND VGND VPWR VPWR sky130_fd_sc_hd__decap_4
XFILLER_43_133 VGND VGND VPWR VPWR sky130_fd_sc_hd__fill_1
XFILLER_71_497 VGND VGND VPWR VPWR sky130_fd_sc_hd__decap_6
XFILLER_101_81 VPWR VGND VPWR VGND sky130_ef_sc_hd__decap_12
XTAP_TAPCELL_ROW_100_1326 VGND VPWR sky130_fd_sc_hd__tapvpwrvgnd_1
XFILLER_12_531 VGND VGND VPWR VPWR sky130_fd_sc_hd__fill_1
XFILLER_8_513 VPWR VGND VPWR VGND sky130_ef_sc_hd__decap_12
XFILLER_8_557 VPWR VGND VPWR VGND sky130_ef_sc_hd__decap_12
XANTENNA_7 net272 VGND VGND VPWR VPWR sky130_fd_sc_hd__diode_2
XFILLER_98_306 VGND VGND VPWR VPWR sky130_fd_sc_hd__fill_2
X_2120_ lsu.load_counter\[9\] _1609_ VGND VGND VPWR VPWR _1610_ sky130_fd_sc_hd__and2_1
XFILLER_94_589 VGND VGND VPWR VPWR sky130_fd_sc_hd__decap_4
XTAP_TAPCELL_ROW_65_949 VGND VPWR sky130_fd_sc_hd__tapvpwrvgnd_1
XFILLER_34_155 VGND VGND VPWR VPWR sky130_fd_sc_hd__decap_3
X_2953_ net325 net1188 net217 VGND VGND VPWR VPWR _0464_ sky130_fd_sc_hd__mux2_1
X_2884_ net522 net330 net195 VGND VGND VPWR VPWR _0395_ sky130_fd_sc_hd__mux2_1
X_4623_ clknet_leaf_31_clk _0680_ VGND VGND VPWR VPWR lsu.load_fifo.queue\[15\]\[7\]
+ sky130_fd_sc_hd__dfxtp_1
X_4554_ clknet_leaf_22_clk _0611_ VGND VGND VPWR VPWR lsu.load_fifo.queue\[0\]\[2\]
+ sky130_fd_sc_hd__dfxtp_1
Xhold502 lsu.load_fifo.queue\[9\]\[4\] VGND VGND VPWR VPWR net970 sky130_fd_sc_hd__dlygate4sd3_1
X_3505_ net437 VGND VGND VPWR VPWR _0069_ sky130_fd_sc_hd__inv_2
Xhold524 lsu.load_fifo.queue\[8\]\[6\] VGND VGND VPWR VPWR net992 sky130_fd_sc_hd__dlygate4sd3_1
Xhold513 lsu.store_fifo.queue\[9\]\[1\] VGND VGND VPWR VPWR net981 sky130_fd_sc_hd__dlygate4sd3_1
Xhold535 lsu.load_fifo.queue\[15\]\[22\] VGND VGND VPWR VPWR net1003 sky130_fd_sc_hd__dlygate4sd3_1
XFILLER_89_317 VGND VGND VPWR VPWR sky130_fd_sc_hd__decap_3
Xhold546 lsu.load_fifo.queue\[10\]\[29\] VGND VGND VPWR VPWR net1014 sky130_fd_sc_hd__dlygate4sd3_1
X_4485_ clknet_leaf_23_clk _0542_ VGND VGND VPWR VPWR lsu.load_fifo.queue\[3\]\[29\]
+ sky130_fd_sc_hd__dfxtp_1
XTAP_TAPCELL_ROW_77_1074 VGND VPWR sky130_fd_sc_hd__tapvpwrvgnd_1
Xhold568 lsu.load_fifo.queue\[11\]\[6\] VGND VGND VPWR VPWR net1036 sky130_fd_sc_hd__dlygate4sd3_1
Xhold579 lsu.load_fifo.queue\[11\]\[1\] VGND VGND VPWR VPWR net1047 sky130_fd_sc_hd__dlygate4sd3_1
Xhold557 lsu.load_fifo.queue\[12\]\[15\] VGND VGND VPWR VPWR net1025 sky130_fd_sc_hd__dlygate4sd3_1
X_3436_ net554 net275 _2059_ VGND VGND VPWR VPWR _1094_ sky130_fd_sc_hd__mux2_1
X_3367_ net322 net1096 net172 VGND VGND VPWR VPWR _0976_ sky130_fd_sc_hd__mux2_1
X_2318_ net266 _1726_ net239 VGND VGND VPWR VPWR _1765_ sky130_fd_sc_hd__o21ai_1
XFILLER_85_578 VPWR VGND VPWR VGND sky130_ef_sc_hd__decap_12
X_3298_ net328 net51 net248 VGND VGND VPWR VPWR _0860_ sky130_fd_sc_hd__mux2_1
X_5037_ clknet_leaf_49_clk _1092_ VGND VGND VPWR VPWR lsu.store_fifo.queue\[12\]\[6\]
+ sky130_fd_sc_hd__dfxtp_1
X_2249_ lsu.storer_state\[2\] lsu.storer_state\[1\] VGND VGND VPWR VPWR _1714_ sky130_fd_sc_hd__nor2_1
XFILLER_72_206 VGND VGND VPWR VPWR sky130_fd_sc_hd__fill_2
XTAP_TAPCELL_ROW_0_221 VGND VPWR sky130_fd_sc_hd__tapvpwrvgnd_1
XFILLER_26_601 VGND VGND VPWR VPWR sky130_fd_sc_hd__decap_8
XFILLER_82_29 VGND VGND VPWR VPWR sky130_fd_sc_hd__decap_3
XTAP_TAPCELL_ROW_0_232 VGND VPWR sky130_fd_sc_hd__tapvpwrvgnd_1
XFILLER_25_199 VGND VGND VPWR VPWR sky130_fd_sc_hd__fill_1
XFILLER_15_78 VGND VGND VPWR VPWR sky130_fd_sc_hd__fill_1
XFILLER_5_505 VPWR VGND VPWR VGND sky130_ef_sc_hd__decap_12
XFILLER_103_3 VPWR VGND VPWR VGND sky130_ef_sc_hd__decap_12
XTAP_TAPCELL_ROW_8_321 VGND VPWR sky130_fd_sc_hd__tapvpwrvgnd_1
XFILLER_0_221 VGND VGND VPWR VPWR sky130_fd_sc_hd__decap_3
Xinput100 store_base_addr[8] VGND VGND VPWR VPWR net100 sky130_fd_sc_hd__clkbuf_1
XFILLER_0_265 VGND VGND VPWR VPWR sky130_fd_sc_hd__decap_8
XFILLER_48_236 VGND VGND VPWR VPWR sky130_fd_sc_hd__decap_6
XFILLER_76_589 VGND VGND VPWR VPWR sky130_fd_sc_hd__decap_4
XFILLER_56_63 VGND VGND VPWR VPWR sky130_fd_sc_hd__fill_1
XFILLER_56_291 VPWR VGND VPWR VGND sky130_ef_sc_hd__decap_12
XTAP_TAPCELL_ROW_62_908 VGND VPWR sky130_fd_sc_hd__tapvpwrvgnd_1
XFILLER_44_497 VGND VGND VPWR VPWR sky130_fd_sc_hd__decap_4
XTAP_TAPCELL_ROW_70_996 VGND VPWR sky130_fd_sc_hd__tapvpwrvgnd_1
XTAP_TAPCELL_ROW_14_389 VGND VPWR sky130_fd_sc_hd__tapvpwrvgnd_1
XTAP_TAPCELL_ROW_42_687 VGND VPWR sky130_fd_sc_hd__tapvpwrvgnd_1
XFILLER_12_394 VPWR VGND VPWR VGND sky130_ef_sc_hd__decap_12
X_4270_ clknet_leaf_54_clk _0327_ VGND VGND VPWR VPWR lsu.load_fifo.queue\[9\]\[8\]
+ sky130_fd_sc_hd__dfxtp_1
XFILLER_97_81 VPWR VGND VPWR VGND sky130_ef_sc_hd__decap_12
XFILLER_86_309 VGND VGND VPWR VPWR sky130_fd_sc_hd__fill_2
X_3221_ net566 net283 _2050_ VGND VGND VPWR VPWR _0757_ sky130_fd_sc_hd__mux2_1
X_3152_ net709 net329 net177 VGND VGND VPWR VPWR _0654_ sky130_fd_sc_hd__mux2_1
X_2103_ _1120_ _1560_ _1119_ VGND VGND VPWR VPWR _1593_ sky130_fd_sc_hd__a21o_1
XFILLER_94_353 VGND VGND VPWR VPWR sky130_fd_sc_hd__fill_2
XFILLER_94_375 VGND VGND VPWR VPWR sky130_fd_sc_hd__fill_1
XFILLER_82_526 VGND VGND VPWR VPWR sky130_fd_sc_hd__fill_1
XFILLER_82_504 VGND VGND VPWR VPWR sky130_fd_sc_hd__decap_6
X_3083_ net335 net1104 net187 VGND VGND VPWR VPWR _0587_ sky130_fd_sc_hd__mux2_1
XFILLER_35_453 VGND VGND VPWR VPWR sky130_fd_sc_hd__fill_1
XFILLER_50_401 VGND VGND VPWR VPWR sky130_fd_sc_hd__decap_4
X_3985_ lsu.load_fifo.queue\[8\]\[2\] lsu.load_fifo.queue\[9\]\[2\] lsu.load_fifo.queue\[10\]\[2\]
+ lsu.load_fifo.queue\[11\]\[2\] net393 net376 VGND VGND VPWR VPWR _1428_ sky130_fd_sc_hd__mux4_1
XFILLER_50_445 VGND VGND VPWR VPWR sky130_fd_sc_hd__fill_1
XFILLER_22_169 VGND VGND VPWR VPWR sky130_fd_sc_hd__decap_8
X_2936_ net739 net292 net219 VGND VGND VPWR VPWR _0448_ sky130_fd_sc_hd__mux2_1
XTAP_TAPCELL_ROW_79_1103 VGND VPWR sky130_fd_sc_hd__tapvpwrvgnd_1
X_2867_ net584 net300 net223 VGND VGND VPWR VPWR _0378_ sky130_fd_sc_hd__mux2_1
X_4606_ clknet_leaf_71_clk _0663_ VGND VGND VPWR VPWR lsu.load_fifo.queue\[8\]\[22\]
+ sky130_fd_sc_hd__dfxtp_1
Xhold310 lsu.load_fifo.queue\[2\]\[9\] VGND VGND VPWR VPWR net778 sky130_fd_sc_hd__dlygate4sd3_1
X_2798_ net284 net878 _2032_ VGND VGND VPWR VPWR _0312_ sky130_fd_sc_hd__mux2_1
Xhold332 _0784_ VGND VGND VPWR VPWR net800 sky130_fd_sc_hd__dlygate4sd3_1
Xhold321 lsu.load_fifo.queue\[6\]\[27\] VGND VGND VPWR VPWR net789 sky130_fd_sc_hd__dlygate4sd3_1
X_4537_ clknet_leaf_69_clk _0594_ VGND VGND VPWR VPWR lsu.load_fifo.queue\[1\]\[17\]
+ sky130_fd_sc_hd__dfxtp_1
Xhold343 lsu.load_fifo.queue\[4\]\[8\] VGND VGND VPWR VPWR net811 sky130_fd_sc_hd__dlygate4sd3_1
Xhold387 _0769_ VGND VGND VPWR VPWR net855 sky130_fd_sc_hd__dlygate4sd3_1
Xhold354 lsu.load_fifo.queue\[10\]\[19\] VGND VGND VPWR VPWR net822 sky130_fd_sc_hd__dlygate4sd3_1
Xhold365 lsu.load_fifo.queue\[11\]\[31\] VGND VGND VPWR VPWR net833 sky130_fd_sc_hd__dlygate4sd3_1
Xhold376 lsu.load_fifo.queue\[10\]\[4\] VGND VGND VPWR VPWR net844 sky130_fd_sc_hd__dlygate4sd3_1
X_4468_ clknet_leaf_18_clk _0525_ VGND VGND VPWR VPWR lsu.load_fifo.queue\[3\]\[12\]
+ sky130_fd_sc_hd__dfxtp_1
XFILLER_89_169 VPWR VGND VPWR VGND sky130_ef_sc_hd__decap_12
X_3419_ net287 net1023 _2058_ VGND VGND VPWR VPWR _1068_ sky130_fd_sc_hd__mux2_1
Xhold398 lsu.load_fifo.queue\[13\]\[5\] VGND VGND VPWR VPWR net866 sky130_fd_sc_hd__dlygate4sd3_1
X_4399_ clknet_leaf_33_clk _0456_ VGND VGND VPWR VPWR lsu.load_fifo.queue\[5\]\[7\]
+ sky130_fd_sc_hd__dfxtp_1
XFILLER_93_39 VPWR VGND VPWR VGND sky130_ef_sc_hd__decap_12
XFILLER_73_548 VPWR VGND VPWR VGND sky130_ef_sc_hd__decap_12
XFILLER_26_11 VGND VGND VPWR VPWR sky130_fd_sc_hd__fill_1
XFILLER_26_486 VPWR VGND VPWR VGND sky130_ef_sc_hd__decap_12
XTAP_TAPCELL_ROW_11_348 VGND VPWR sky130_fd_sc_hd__tapvpwrvgnd_1
XFILLER_5_313 VGND VGND VPWR VPWR sky130_fd_sc_hd__decap_6
XPHY_EDGE_ROW_39_Left_146 VGND VGND VPWR VPWR sky130_fd_sc_hd__decap_3
XFILLER_1_541 VPWR VGND VPWR VGND sky130_ef_sc_hd__decap_12
XFILLER_3_15 VPWR VGND VPWR VGND sky130_ef_sc_hd__decap_12
XFILLER_1_585 VPWR VGND VPWR VGND sky130_ef_sc_hd__decap_12
XFILLER_91_334 VGND VGND VPWR VPWR sky130_fd_sc_hd__fill_2
XFILLER_76_397 VPWR VGND VPWR VGND sky130_ef_sc_hd__decap_12
XTAP_TAPCELL_ROW_19_437 VGND VPWR sky130_fd_sc_hd__tapvpwrvgnd_1
XTAP_TAPCELL_ROW_47_746 VGND VPWR sky130_fd_sc_hd__tapvpwrvgnd_1
XPHY_EDGE_ROW_48_Left_155 VGND VGND VPWR VPWR sky130_fd_sc_hd__decap_3
XFILLER_17_497 VGND VGND VPWR VPWR sky130_fd_sc_hd__decap_6
XFILLER_44_283 VGND VGND VPWR VPWR sky130_fd_sc_hd__decap_3
XTAP_TAPCELL_ROW_106_1398 VGND VPWR sky130_fd_sc_hd__tapvpwrvgnd_1
XFILLER_20_629 VGND VGND VPWR VPWR sky130_fd_sc_hd__fill_1
X_3770_ net288 _1243_ _1125_ VGND VGND VPWR VPWR _1077_ sky130_fd_sc_hd__mux2_1
X_2721_ net519 net285 _2025_ VGND VGND VPWR VPWR _0242_ sky130_fd_sc_hd__mux2_1
Xlsu_wrapper_462 VGND VGND VPWR VPWR lsu_wrapper_462/HI store_data[25] sky130_fd_sc_hd__conb_1
Xlsu_wrapper_451 VGND VGND VPWR VPWR lsu_wrapper_451/HI store_data[14] sky130_fd_sc_hd__conb_1
X_2652_ net286 net1053 _2019_ VGND VGND VPWR VPWR _0179_ sky130_fd_sc_hd__mux2_1
XPHY_EDGE_ROW_57_Left_164 VGND VGND VPWR VPWR sky130_fd_sc_hd__decap_3
X_2583_ lsu.current_load_addr\[7\] _1974_ net162 VGND VGND VPWR VPWR _0734_ sky130_fd_sc_hd__mux2_4
XTAP_TAPCELL_ROW_74_1044 VGND VPWR sky130_fd_sc_hd__tapvpwrvgnd_1
X_4322_ clknet_leaf_16_clk _0379_ VGND VGND VPWR VPWR lsu.load_fifo.queue\[10\]\[28\]
+ sky130_fd_sc_hd__dfxtp_1
X_4253_ clknet_leaf_59_clk _0310_ VGND VGND VPWR VPWR lsu.store_fifo.queue\[1\]\[1\]
+ sky130_fd_sc_hd__dfxtp_1
X_3204_ lsu.store_fifo.w_ptr\[3\] lsu.store_fifo.w_ptr\[2\] VGND VGND VPWR VPWR _2048_
+ sky130_fd_sc_hd__nand2_2
X_4184_ clknet_leaf_60_clk _0241_ VGND VGND VPWR VPWR lsu.store_fifo.queue\[8\]\[2\]
+ sky130_fd_sc_hd__dfxtp_1
X_3135_ net502 net296 net183 VGND VGND VPWR VPWR _0638_ sky130_fd_sc_hd__mux2_1
XFILLER_27_217 VGND VGND VPWR VPWR sky130_fd_sc_hd__decap_6
XPHY_EDGE_ROW_66_Left_173 VGND VGND VPWR VPWR sky130_fd_sc_hd__decap_3
XFILLER_103_27 VPWR VGND VPWR VGND sky130_ef_sc_hd__decap_12
X_3066_ net957 net303 net208 VGND VGND VPWR VPWR _0571_ sky130_fd_sc_hd__mux2_1
XTAP_TAPCELL_ROW_85_1162 VGND VPWR sky130_fd_sc_hd__tapvpwrvgnd_1
XFILLER_23_401 VGND VGND VPWR VPWR sky130_fd_sc_hd__decap_3
XFILLER_63_570 VGND VGND VPWR VPWR sky130_fd_sc_hd__decap_8
XFILLER_11_629 VGND VGND VPWR VPWR sky130_fd_sc_hd__fill_1
XFILLER_50_253 VGND VGND VPWR VPWR sky130_fd_sc_hd__decap_4
X_3968_ lsu.load_fifo.queue\[4\]\[4\] lsu.load_fifo.queue\[5\]\[4\] lsu.load_fifo.queue\[6\]\[4\]
+ lsu.load_fifo.queue\[7\]\[4\] net391 net374 VGND VGND VPWR VPWR _1413_ sky130_fd_sc_hd__mux4_1
XPHY_EDGE_ROW_75_Left_182 VGND VGND VPWR VPWR sky130_fd_sc_hd__decap_3
X_2919_ net755 net326 net218 VGND VGND VPWR VPWR _0431_ sky130_fd_sc_hd__mux2_1
X_3899_ lsu.load_fifo.queue\[0\]\[14\] lsu.load_fifo.queue\[1\]\[14\] lsu.load_fifo.queue\[2\]\[14\]
+ lsu.load_fifo.queue\[3\]\[14\] net385 net368 VGND VGND VPWR VPWR _1354_ sky130_fd_sc_hd__mux4_1
Xhold162 net123 VGND VGND VPWR VPWR net630 sky130_fd_sc_hd__dlygate4sd3_1
XTAP_TAPCELL_ROW_96_1291 VGND VPWR sky130_fd_sc_hd__tapvpwrvgnd_1
Xhold140 lsu.store_fifo.queue\[6\]\[6\] VGND VGND VPWR VPWR net608 sky130_fd_sc_hd__dlygate4sd3_1
Xhold151 lsu.store_fifo.queue\[6\]\[0\] VGND VGND VPWR VPWR net619 sky130_fd_sc_hd__dlygate4sd3_1
Xhold195 lsu.load_fifo.queue\[15\]\[16\] VGND VGND VPWR VPWR net663 sky130_fd_sc_hd__dlygate4sd3_1
Xhold184 lsu.store_fifo.queue\[13\]\[7\] VGND VGND VPWR VPWR net652 sky130_fd_sc_hd__dlygate4sd3_1
Xhold173 lsu.load_fifo.queue\[7\]\[26\] VGND VGND VPWR VPWR net641 sky130_fd_sc_hd__dlygate4sd3_1
XPHY_EDGE_ROW_84_Left_191 VGND VGND VPWR VPWR sky130_fd_sc_hd__decap_3
XFILLER_100_450 VGND VGND VPWR VPWR sky130_fd_sc_hd__fill_2
XFILLER_92_109 VPWR VGND VPWR VGND sky130_ef_sc_hd__decap_12
XFILLER_37_54 VGND VGND VPWR VPWR sky130_fd_sc_hd__fill_2
XTAP_TAPCELL_ROW_16_407 VGND VPWR sky130_fd_sc_hd__tapvpwrvgnd_1
XFILLER_26_250 VGND VGND VPWR VPWR sky130_fd_sc_hd__fill_2
XTAP_TAPCELL_ROW_44_716 VGND VPWR sky130_fd_sc_hd__tapvpwrvgnd_1
XFILLER_14_445 VPWR VGND VPWR VGND sky130_ef_sc_hd__decap_12
XFILLER_41_231 VGND VGND VPWR VPWR sky130_fd_sc_hd__fill_2
XFILLER_41_242 VGND VGND VPWR VPWR sky130_fd_sc_hd__fill_1
XFILLER_53_53 VGND VGND VPWR VPWR sky130_fd_sc_hd__decap_3
XFILLER_14_489 VPWR VGND VPWR VGND sky130_ef_sc_hd__decap_12
XTAP_TAPCELL_ROW_24_495 VGND VPWR sky130_fd_sc_hd__tapvpwrvgnd_1
XFILLER_5_165 VGND VGND VPWR VPWR sky130_fd_sc_hd__decap_3
XFILLER_78_83 VGND VGND VPWR VPWR sky130_fd_sc_hd__fill_1
XFILLER_1_393 VPWR VGND VPWR VGND sky130_ef_sc_hd__decap_12
XFILLER_37_548 VGND VGND VPWR VPWR sky130_fd_sc_hd__decap_3
XFILLER_17_250 VGND VGND VPWR VPWR sky130_fd_sc_hd__decap_6
X_4940_ clknet_leaf_64_clk _0995_ _0126_ VGND VGND VPWR VPWR net152 sky130_fd_sc_hd__dfrtp_1
X_4871_ clknet_leaf_41_clk _0926_ _0121_ VGND VGND VPWR VPWR lsu.load_counter\[21\]
+ sky130_fd_sc_hd__dfrtp_1
X_3822_ lsu.load_fifo.queue\[4\]\[25\] lsu.load_fifo.queue\[5\]\[25\] lsu.load_fifo.queue\[6\]\[25\]
+ lsu.load_fifo.queue\[7\]\[25\] net388 net371 VGND VGND VPWR VPWR _1288_ sky130_fd_sc_hd__mux4_1
XFILLER_20_459 VGND VGND VPWR VPWR sky130_fd_sc_hd__fill_1
X_3753_ net274 _1126_ _1232_ _1233_ VGND VGND VPWR VPWR _1084_ sky130_fd_sc_hd__a22o_1
X_2704_ net833 net293 net231 VGND VGND VPWR VPWR _0228_ sky130_fd_sc_hd__mux2_1
X_3684_ acc.byte3\[6\] acc.byte2\[6\] VGND VGND VPWR VPWR _1166_ sky130_fd_sc_hd__or2_1
X_2635_ _2007_ _2008_ _2010_ lsu.store_fifo.w_en VGND VGND VPWR VPWR _2011_ sky130_fd_sc_hd__o31a_2
X_2566_ net259 _1926_ VGND VGND VPWR VPWR _1962_ sky130_fd_sc_hd__nor2_1
XFILLER_99_242 VPWR VGND VPWR VGND sky130_ef_sc_hd__decap_12
X_4305_ clknet_leaf_1_clk _0362_ VGND VGND VPWR VPWR lsu.load_fifo.queue\[10\]\[11\]
+ sky130_fd_sc_hd__dfxtp_1
XFILLER_101_203 VGND VGND VPWR VPWR sky130_fd_sc_hd__decap_4
X_2497_ net102 net267 _1838_ VGND VGND VPWR VPWR _0765_ sky130_fd_sc_hd__o21ai_1
X_4236_ clknet_leaf_56_clk _0293_ VGND VGND VPWR VPWR lsu.store_fifo.queue\[3\]\[4\]
+ sky130_fd_sc_hd__dfxtp_1
XFILLER_59_139 VPWR VGND VPWR VGND sky130_ef_sc_hd__decap_12
X_4167_ clknet_leaf_78_clk _0224_ VGND VGND VPWR VPWR lsu.load_fifo.queue\[11\]\[27\]
+ sky130_fd_sc_hd__dfxtp_1
XFILLER_95_492 VGND VGND VPWR VPWR sky130_fd_sc_hd__fill_1
X_3118_ net573 net331 net183 VGND VGND VPWR VPWR _0621_ sky130_fd_sc_hd__mux2_1
X_4098_ lsu.store_fifo.queue\[8\]\[1\] lsu.store_fifo.queue\[9\]\[1\] lsu.store_fifo.queue\[10\]\[1\]
+ lsu.store_fifo.queue\[11\]\[1\] net412 net407 VGND VGND VPWR VPWR _1530_ sky130_fd_sc_hd__mux4_1
X_3049_ net778 net336 net206 VGND VGND VPWR VPWR _0554_ sky130_fd_sc_hd__mux2_1
XFILLER_43_529 VGND VGND VPWR VPWR sky130_fd_sc_hd__fill_1
XFILLER_90_29 VPWR VGND VPWR VGND sky130_ef_sc_hd__decap_12
XFILLER_51_573 VGND VGND VPWR VPWR sky130_fd_sc_hd__decap_6
XFILLER_23_45 VGND VGND VPWR VPWR sky130_fd_sc_hd__decap_8
XTAP_TAPCELL_ROW_21_465 VGND VPWR sky130_fd_sc_hd__tapvpwrvgnd_1
XFILLER_2_157 VGND VGND VPWR VPWR sky130_fd_sc_hd__fill_2
XFILLER_2_179 VGND VGND VPWR VPWR sky130_fd_sc_hd__fill_1
XFILLER_78_448 VGND VGND VPWR VPWR sky130_fd_sc_hd__fill_1
XFILLER_93_418 VGND VGND VPWR VPWR sky130_fd_sc_hd__decap_6
XFILLER_86_492 VGND VGND VPWR VPWR sky130_fd_sc_hd__fill_2
XFILLER_0_27 VGND VGND VPWR VPWR sky130_fd_sc_hd__fill_1
XFILLER_19_559 VGND VGND VPWR VPWR sky130_fd_sc_hd__fill_1
XTAP_TAPCELL_ROW_29_554 VGND VPWR sky130_fd_sc_hd__tapvpwrvgnd_1
XTAP_TAPCELL_ROW_57_852 VGND VPWR sky130_fd_sc_hd__tapvpwrvgnd_1
XFILLER_58_194 VGND VGND VPWR VPWR sky130_fd_sc_hd__fill_2
XFILLER_61_315 VGND VGND VPWR VPWR sky130_fd_sc_hd__fill_1
XTAP_TAPCELL_ROW_103_1368 VGND VPWR sky130_fd_sc_hd__tapvpwrvgnd_1
X_2420_ lsu.current_store_addr\[20\] lsu.current_store_addr\[19\] _1855_ VGND VGND
+ VPWR VPWR _1856_ sky130_fd_sc_hd__and3_1
XFILLER_89_93 VPWR VGND VPWR VGND sky130_ef_sc_hd__decap_12
X_2351_ net470 _1587_ lsu.store_counter\[14\] VGND VGND VPWR VPWR _1790_ sky130_fd_sc_hd__a21oi_1
XTAP_TAPCELL_ROW_71_1014 VGND VPWR sky130_fd_sc_hd__tapvpwrvgnd_1
XFILLER_96_245 VGND VGND VPWR VPWR sky130_fd_sc_hd__decap_6
X_2282_ net266 _1733_ net241 VGND VGND VPWR VPWR _1743_ sky130_fd_sc_hd__o21ai_1
X_4021_ lsu.store_fifo.queue\[8\]\[8\] lsu.store_fifo.queue\[9\]\[8\] lsu.store_fifo.queue\[10\]\[8\]
+ lsu.store_fifo.queue\[11\]\[8\] net414 net410 VGND VGND VPWR VPWR _1460_ sky130_fd_sc_hd__mux4_1
XFILLER_96_289 VPWR VGND VPWR VGND sky130_ef_sc_hd__decap_12
XFILLER_37_301 VGND VGND VPWR VPWR sky130_fd_sc_hd__decap_3
XFILLER_37_389 VGND VGND VPWR VPWR sky130_fd_sc_hd__decap_3
XFILLER_52_304 VGND VGND VPWR VPWR sky130_fd_sc_hd__decap_4
XTAP_TAPCELL_ROW_82_1132 VGND VPWR sky130_fd_sc_hd__tapvpwrvgnd_1
X_4923_ clknet_leaf_2_clk _0978_ VGND VGND VPWR VPWR lsu.load_fifo.queue\[13\]\[18\]
+ sky130_fd_sc_hd__dfxtp_1
X_4854_ clknet_leaf_39_clk _0909_ _0104_ VGND VGND VPWR VPWR lsu.load_counter\[4\]
+ sky130_fd_sc_hd__dfrtp_1
XFILLER_60_381 VGND VGND VPWR VPWR sky130_fd_sc_hd__decap_4
X_4785_ clknet_leaf_59_clk _0842_ VGND VGND VPWR VPWR lsu.store_fifo.queue\[0\]\[5\]
+ sky130_fd_sc_hd__dfxtp_1
X_3805_ lsu.load_fifo.queue\[8\]\[28\] lsu.load_fifo.queue\[9\]\[28\] lsu.load_fifo.queue\[10\]\[28\]
+ lsu.load_fifo.queue\[11\]\[28\] net392 net375 VGND VGND VPWR VPWR _1274_ sky130_fd_sc_hd__mux4_1
X_3736_ _1143_ _1216_ _1217_ VGND VGND VPWR VPWR _1218_ sky130_fd_sc_hd__or3_1
Xclkload71 clknet_leaf_38_clk VGND VGND VPWR VPWR clkload71/Y sky130_fd_sc_hd__inv_6
Xclkload60 clknet_leaf_59_clk VGND VGND VPWR VPWR clkload60/Y sky130_fd_sc_hd__clkinvlp_4
X_3667_ _1138_ _1148_ _1137_ VGND VGND VPWR VPWR _1149_ sky130_fd_sc_hd__a21bo_1
XTAP_TAPCELL_ROW_93_1250 VGND VPWR sky130_fd_sc_hd__tapvpwrvgnd_1
X_2618_ lsu.load_fifo.w_ptr\[1\] lsu.load_fifo.w_ptr\[0\] _1996_ VGND VGND VPWR VPWR
+ _1998_ sky130_fd_sc_hd__and3_1
Xclkload82 clknet_leaf_46_clk VGND VGND VPWR VPWR clkload82/Y sky130_fd_sc_hd__inv_6
X_3598_ net427 VGND VGND VPWR VPWR _0162_ sky130_fd_sc_hd__inv_2
X_2549_ lsu.current_load_addr\[15\] _1928_ VGND VGND VPWR VPWR _1949_ sky130_fd_sc_hd__or2_1
XFILLER_0_617 VPWR VGND VPWR VGND sky130_ef_sc_hd__decap_12
XFILLER_87_223 VGND VGND VPWR VPWR sky130_fd_sc_hd__fill_1
XFILLER_102_589 VPWR VGND VPWR VGND sky130_ef_sc_hd__decap_12
XFILLER_85_18 VPWR VGND VPWR VGND sky130_ef_sc_hd__decap_12
X_4219_ clknet_leaf_58_clk _0276_ VGND VGND VPWR VPWR lsu.store_fifo.queue\[5\]\[7\]
+ sky130_fd_sc_hd__dfxtp_1
XTAP_TAPCELL_ROW_26_513 VGND VPWR sky130_fd_sc_hd__tapvpwrvgnd_1
XTAP_TAPCELL_ROW_54_822 VGND VPWR sky130_fd_sc_hd__tapvpwrvgnd_1
XFILLER_43_337 VGND VGND VPWR VPWR sky130_fd_sc_hd__decap_8
XFILLER_43_359 VGND VGND VPWR VPWR sky130_fd_sc_hd__fill_2
XFILLER_11_223 VGND VGND VPWR VPWR sky130_fd_sc_hd__fill_1
XFILLER_11_289 VGND VGND VPWR VPWR sky130_fd_sc_hd__fill_1
XFILLER_11_278 VGND VGND VPWR VPWR sky130_fd_sc_hd__fill_2
XFILLER_105_350 VGND VGND VPWR VPWR sky130_fd_sc_hd__decap_6
XFILLER_66_418 VGND VGND VPWR VPWR sky130_fd_sc_hd__fill_2
XFILLER_93_237 VPWR VGND VPWR VGND sky130_ef_sc_hd__decap_12
XTAP_TAPCELL_ROW_6_293 VGND VPWR sky130_fd_sc_hd__tapvpwrvgnd_1
Xfanout280 net281 VGND VGND VPWR VPWR net280 sky130_fd_sc_hd__clkbuf_2
Xfanout291 acc.data_out\[0\] VGND VGND VPWR VPWR net291 sky130_fd_sc_hd__buf_1
XFILLER_19_334 VGND VGND VPWR VPWR sky130_fd_sc_hd__fill_2
XFILLER_19_345 VGND VGND VPWR VPWR sky130_fd_sc_hd__fill_2
XFILLER_46_153 VGND VGND VPWR VPWR sky130_fd_sc_hd__decap_6
XFILLER_15_573 VPWR VGND VPWR VGND sky130_ef_sc_hd__decap_12
X_4570_ clknet_leaf_8_clk _0627_ VGND VGND VPWR VPWR lsu.load_fifo.queue\[0\]\[18\]
+ sky130_fd_sc_hd__dfxtp_1
XFILLER_30_598 VGND VGND VPWR VPWR sky130_fd_sc_hd__decap_3
X_3521_ net440 VGND VGND VPWR VPWR _0085_ sky130_fd_sc_hd__inv_2
Xhold706 lsu.load_fifo.queue\[13\]\[14\] VGND VGND VPWR VPWR net1174 sky130_fd_sc_hd__dlygate4sd3_1
Xhold717 lsu.load_fifo.queue\[12\]\[18\] VGND VGND VPWR VPWR net1185 sky130_fd_sc_hd__dlygate4sd3_1
Xhold728 net128 VGND VGND VPWR VPWR net1196 sky130_fd_sc_hd__dlygate4sd3_1
X_3452_ net426 VGND VGND VPWR VPWR _0016_ sky130_fd_sc_hd__inv_2
Xhold739 lsu.load_fifo.queue\[14\]\[7\] VGND VGND VPWR VPWR net1207 sky130_fd_sc_hd__dlygate4sd3_1
XFILLER_6_282 VPWR VGND VPWR VGND sky130_ef_sc_hd__decap_12
X_2403_ net93 net242 _1720_ VGND VGND VPWR VPWR _1839_ sky130_fd_sc_hd__a21o_1
X_3383_ net416 net418 _2034_ VGND VGND VPWR VPWR _2057_ sky130_fd_sc_hd__and3_2
XFILLER_97_532 VGND VGND VPWR VPWR sky130_fd_sc_hd__decap_4
XFILLER_97_521 VGND VGND VPWR VPWR sky130_fd_sc_hd__decap_3
X_2334_ lsu.load_fifo.w_en lsu.load_fifo.r_en VGND VGND VPWR VPWR _1774_ sky130_fd_sc_hd__nand2_1
X_2265_ lsu.store_counter\[11\] lsu.store_counter\[10\] _1729_ VGND VGND VPWR VPWR
+ _1730_ sky130_fd_sc_hd__and3_1
X_2196_ net167 net164 _1675_ net244 lsu.load_counter\[18\] VGND VGND VPWR VPWR _1683_
+ sky130_fd_sc_hd__o2111a_1
X_4004_ net409 net420 VGND VGND VPWR VPWR _1444_ sky130_fd_sc_hd__nand2b_1
XFILLER_1_81 VPWR VGND VPWR VGND sky130_ef_sc_hd__decap_12
XFILLER_37_175 VGND VGND VPWR VPWR sky130_fd_sc_hd__fill_1
XFILLER_52_167 VGND VGND VPWR VPWR sky130_fd_sc_hd__fill_1
X_4906_ clknet_leaf_77_clk _0961_ VGND VGND VPWR VPWR lsu.load_fifo.queue\[13\]\[1\]
+ sky130_fd_sc_hd__dfxtp_1
XFILLER_40_318 VPWR VGND VPWR VGND sky130_ef_sc_hd__decap_12
X_4837_ clknet_leaf_45_clk _0894_ _0087_ VGND VGND VPWR VPWR lsu.store_counter\[14\]
+ sky130_fd_sc_hd__dfrtp_1
XTAP_TAPCELL_ROW_31_571 VGND VPWR sky130_fd_sc_hd__tapvpwrvgnd_1
X_4768_ clknet_leaf_48_clk net947 VGND VGND VPWR VPWR net132 sky130_fd_sc_hd__dfxtp_1
X_4699_ clknet_leaf_60_clk _0756_ VGND VGND VPWR VPWR lsu.store_fifo.queue\[14\]\[3\]
+ sky130_fd_sc_hd__dfxtp_1
X_3719_ _1145_ _1147_ VGND VGND VPWR VPWR _1201_ sky130_fd_sc_hd__xnor2_1
XFILLER_48_418 VGND VGND VPWR VPWR sky130_fd_sc_hd__fill_2
XFILLER_75_237 VGND VGND VPWR VPWR sky130_fd_sc_hd__decap_4
Xhold33 lsu.store_fifo.queue\[14\]\[5\] VGND VGND VPWR VPWR net501 sky130_fd_sc_hd__dlygate4sd3_1
Xhold55 lsu.store_fifo.queue\[8\]\[2\] VGND VGND VPWR VPWR net523 sky130_fd_sc_hd__dlygate4sd3_1
Xhold44 lsu.load_fifo.queue\[10\]\[28\] VGND VGND VPWR VPWR net512 sky130_fd_sc_hd__dlygate4sd3_1
Xhold66 _0777_ VGND VGND VPWR VPWR net534 sky130_fd_sc_hd__dlygate4sd3_1
Xhold88 lsu.load_fifo.queue\[7\]\[29\] VGND VGND VPWR VPWR net556 sky130_fd_sc_hd__dlygate4sd3_1
Xhold99 lsu.load_fifo.queue\[11\]\[12\] VGND VGND VPWR VPWR net567 sky130_fd_sc_hd__dlygate4sd3_1
Xhold77 lsu.load_fifo.queue\[0\]\[31\] VGND VGND VPWR VPWR net545 sky130_fd_sc_hd__dlygate4sd3_1
XPHY_EDGE_ROW_11_Left_118 VGND VGND VPWR VPWR sky130_fd_sc_hd__decap_3
XTAP_TAPCELL_ROW_3_263 VGND VPWR sky130_fd_sc_hd__tapvpwrvgnd_1
XTAP_TAPCELL_ROW_39_660 VGND VPWR sky130_fd_sc_hd__tapvpwrvgnd_1
XFILLER_83_281 VGND VGND VPWR VPWR sky130_fd_sc_hd__fill_2
XFILLER_71_410 VPWR VGND VPWR VGND sky130_ef_sc_hd__decap_12
XFILLER_56_495 VPWR VGND VPWR VGND sky130_ef_sc_hd__decap_12
XFILLER_101_93 VGND VGND VPWR VPWR sky130_fd_sc_hd__decap_6
XTAP_TAPCELL_ROW_100_1327 VGND VPWR sky130_fd_sc_hd__tapvpwrvgnd_1
XFILLER_12_587 VGND VGND VPWR VPWR sky130_fd_sc_hd__fill_1
XFILLER_8_525 VGND VGND VPWR VPWR sky130_fd_sc_hd__decap_6
XFILLER_8_569 VPWR VGND VPWR VGND sky130_ef_sc_hd__decap_12
XFILLER_6_15 VPWR VGND VPWR VGND sky130_ef_sc_hd__decap_12
XANTENNA_8 _2055_ VGND VGND VPWR VPWR sky130_fd_sc_hd__diode_2
XPHY_EDGE_ROW_20_Left_127 VGND VGND VPWR VPWR sky130_fd_sc_hd__decap_3
XFILLER_79_554 VGND VGND VPWR VPWR sky130_fd_sc_hd__fill_1
XFILLER_94_513 VGND VGND VPWR VPWR sky130_fd_sc_hd__decap_8
XFILLER_86_83 VGND VGND VPWR VPWR sky130_fd_sc_hd__fill_1
XFILLER_19_142 VGND VGND VPWR VPWR sky130_fd_sc_hd__decap_8
XFILLER_34_145 VGND VGND VPWR VPWR sky130_fd_sc_hd__fill_1
XFILLER_96_3 VPWR VGND VPWR VGND sky130_ef_sc_hd__decap_12
X_2952_ net326 net1230 net214 VGND VGND VPWR VPWR _0463_ sky130_fd_sc_hd__mux2_1
X_2883_ net858 net332 net193 VGND VGND VPWR VPWR _0394_ sky130_fd_sc_hd__mux2_1
X_4622_ clknet_leaf_0_clk _0679_ VGND VGND VPWR VPWR lsu.load_fifo.queue\[15\]\[6\]
+ sky130_fd_sc_hd__dfxtp_1
X_4553_ clknet_leaf_77_clk _0610_ VGND VGND VPWR VPWR lsu.load_fifo.queue\[0\]\[1\]
+ sky130_fd_sc_hd__dfxtp_1
X_3504_ net444 VGND VGND VPWR VPWR _0068_ sky130_fd_sc_hd__inv_2
X_4484_ clknet_leaf_15_clk _0541_ VGND VGND VPWR VPWR lsu.load_fifo.queue\[3\]\[28\]
+ sky130_fd_sc_hd__dfxtp_1
Xhold514 lsu.load_fifo.queue\[10\]\[9\] VGND VGND VPWR VPWR net982 sky130_fd_sc_hd__dlygate4sd3_1
Xhold503 lsu.load_fifo.queue\[14\]\[17\] VGND VGND VPWR VPWR net971 sky130_fd_sc_hd__dlygate4sd3_1
Xhold525 lsu.store_fifo.queue\[1\]\[4\] VGND VGND VPWR VPWR net993 sky130_fd_sc_hd__dlygate4sd3_1
Xhold536 lsu.load_fifo.queue\[8\]\[30\] VGND VGND VPWR VPWR net1004 sky130_fd_sc_hd__dlygate4sd3_1
Xhold547 lsu.load_fifo.queue\[14\]\[10\] VGND VGND VPWR VPWR net1015 sky130_fd_sc_hd__dlygate4sd3_1
XTAP_TAPCELL_ROW_77_1075 VGND VPWR sky130_fd_sc_hd__tapvpwrvgnd_1
Xhold569 lsu.load_fifo.queue\[15\]\[7\] VGND VGND VPWR VPWR net1037 sky130_fd_sc_hd__dlygate4sd3_1
Xhold558 lsu.load_fifo.queue\[6\]\[7\] VGND VGND VPWR VPWR net1026 sky130_fd_sc_hd__dlygate4sd3_1
X_3435_ net697 net276 _2059_ VGND VGND VPWR VPWR _1093_ sky130_fd_sc_hd__mux2_1
XFILLER_106_27 VGND VGND VPWR VPWR sky130_fd_sc_hd__fill_1
XTAP_TAPCELL_ROW_90_1220 VGND VPWR sky130_fd_sc_hd__tapvpwrvgnd_1
XFILLER_85_502 VGND VGND VPWR VPWR sky130_fd_sc_hd__fill_2
X_3366_ net324 net1110 net171 VGND VGND VPWR VPWR _0975_ sky130_fd_sc_hd__mux2_1
X_2317_ lsu.store_counter\[4\] _1721_ VGND VGND VPWR VPWR _1764_ sky130_fd_sc_hd__nor2_1
X_3297_ net330 net50 net250 VGND VGND VPWR VPWR _0859_ sky130_fd_sc_hd__mux2_1
X_2248_ lsu.storer_state\[1\] lsu.storer_state\[0\] VGND VGND VPWR VPWR _1713_ sky130_fd_sc_hd__nor2_1
X_5036_ clknet_leaf_59_clk _1091_ VGND VGND VPWR VPWR lsu.store_fifo.queue\[12\]\[5\]
+ sky130_fd_sc_hd__dfxtp_1
XFILLER_38_473 VGND VGND VPWR VPWR sky130_fd_sc_hd__decap_3
X_2179_ lsu.load_counter\[5\] lsu.load_counter\[4\] _1668_ VGND VGND VPWR VPWR _1669_
+ sky130_fd_sc_hd__and3_1
XTAP_TAPCELL_ROW_88_1193 VGND VPWR sky130_fd_sc_hd__tapvpwrvgnd_1
XTAP_TAPCELL_ROW_0_222 VGND VPWR sky130_fd_sc_hd__tapvpwrvgnd_1
XTAP_TAPCELL_ROW_0_233 VGND VPWR sky130_fd_sc_hd__tapvpwrvgnd_1
XTAP_TAPCELL_ROW_36_630 VGND VPWR sky130_fd_sc_hd__tapvpwrvgnd_1
XFILLER_15_57 VGND VGND VPWR VPWR sky130_fd_sc_hd__decap_6
XFILLER_15_35 VGND VGND VPWR VPWR sky130_fd_sc_hd__decap_4
XFILLER_5_517 VPWR VGND VPWR VGND sky130_ef_sc_hd__decap_12
XTAP_TAPCELL_ROW_8_322 VGND VPWR sky130_fd_sc_hd__tapvpwrvgnd_1
Xinput101 store_base_addr[9] VGND VGND VPWR VPWR net101 sky130_fd_sc_hd__clkbuf_1
XFILLER_48_226 VGND VGND VPWR VPWR sky130_fd_sc_hd__fill_1
XFILLER_91_505 VGND VGND VPWR VPWR sky130_fd_sc_hd__decap_6
XFILLER_44_421 VGND VGND VPWR VPWR sky130_fd_sc_hd__decap_6
XTAP_TAPCELL_ROW_62_909 VGND VPWR sky130_fd_sc_hd__tapvpwrvgnd_1
XTAP_TAPCELL_ROW_70_997 VGND VPWR sky130_fd_sc_hd__tapvpwrvgnd_1
XTAP_TAPCELL_ROW_14_379 VGND VPWR sky130_fd_sc_hd__tapvpwrvgnd_1
XTAP_TAPCELL_ROW_42_688 VGND VPWR sky130_fd_sc_hd__tapvpwrvgnd_1
X_3220_ net524 net285 _2050_ VGND VGND VPWR VPWR _0756_ sky130_fd_sc_hd__mux2_1
XFILLER_100_109 VGND VGND VPWR VPWR sky130_fd_sc_hd__decap_4
XFILLER_97_93 VPWR VGND VPWR VGND sky130_ef_sc_hd__decap_12
X_3151_ net536 net331 net179 VGND VGND VPWR VPWR _0653_ sky130_fd_sc_hd__mux2_1
X_2102_ lsu.load_counter\[12\] _1591_ VGND VGND VPWR VPWR _1592_ sky130_fd_sc_hd__or2_1
XFILLER_94_321 VPWR VGND VPWR VGND sky130_ef_sc_hd__decap_12
XFILLER_11_3 VGND VGND VPWR VPWR sky130_fd_sc_hd__decap_6
X_3082_ net336 net1140 net185 VGND VGND VPWR VPWR _0586_ sky130_fd_sc_hd__mux2_1
XFILLER_62_251 VGND VGND VPWR VPWR sky130_fd_sc_hd__fill_1
X_3984_ lsu.load_fifo.queue\[12\]\[2\] lsu.load_fifo.queue\[13\]\[2\] lsu.load_fifo.queue\[14\]\[2\]
+ lsu.load_fifo.queue\[15\]\[2\] net393 net376 VGND VGND VPWR VPWR _1427_ sky130_fd_sc_hd__mux4_1
X_2935_ net859 net294 net220 VGND VGND VPWR VPWR _0447_ sky130_fd_sc_hd__mux2_1
XTAP_TAPCELL_ROW_79_1104 VGND VPWR sky130_fd_sc_hd__tapvpwrvgnd_1
X_2866_ net1125 net302 net224 VGND VGND VPWR VPWR _0377_ sky130_fd_sc_hd__mux2_1
X_4605_ clknet_leaf_27_clk _0662_ VGND VGND VPWR VPWR lsu.load_fifo.queue\[8\]\[21\]
+ sky130_fd_sc_hd__dfxtp_1
X_2797_ net286 net1164 _2032_ VGND VGND VPWR VPWR _0311_ sky130_fd_sc_hd__mux2_1
Xhold311 lsu.store_fifo.queue\[13\]\[8\] VGND VGND VPWR VPWR net779 sky130_fd_sc_hd__dlygate4sd3_1
Xhold300 lsu.load_fifo.queue\[14\]\[15\] VGND VGND VPWR VPWR net768 sky130_fd_sc_hd__dlygate4sd3_1
X_4536_ clknet_leaf_32_clk _0593_ VGND VGND VPWR VPWR lsu.load_fifo.queue\[1\]\[16\]
+ sky130_fd_sc_hd__dfxtp_1
Xhold322 lsu.load_fifo.queue\[1\]\[31\] VGND VGND VPWR VPWR net790 sky130_fd_sc_hd__dlygate4sd3_1
Xhold333 lsu.load_fifo.queue\[9\]\[8\] VGND VGND VPWR VPWR net801 sky130_fd_sc_hd__dlygate4sd3_1
Xhold344 lsu.load_fifo.queue\[7\]\[28\] VGND VGND VPWR VPWR net812 sky130_fd_sc_hd__dlygate4sd3_1
X_4467_ clknet_leaf_86_clk _0524_ VGND VGND VPWR VPWR lsu.load_fifo.queue\[3\]\[11\]
+ sky130_fd_sc_hd__dfxtp_1
Xhold377 lsu.load_fifo.queue\[12\]\[6\] VGND VGND VPWR VPWR net845 sky130_fd_sc_hd__dlygate4sd3_1
Xhold366 lsu.load_fifo.queue\[13\]\[17\] VGND VGND VPWR VPWR net834 sky130_fd_sc_hd__dlygate4sd3_1
Xhold355 lsu.store_fifo.queue\[2\]\[9\] VGND VGND VPWR VPWR net823 sky130_fd_sc_hd__dlygate4sd3_1
Xhold399 net115 VGND VGND VPWR VPWR net867 sky130_fd_sc_hd__dlygate4sd3_1
X_4398_ clknet_leaf_0_clk _0455_ VGND VGND VPWR VPWR lsu.load_fifo.queue\[5\]\[6\]
+ sky130_fd_sc_hd__dfxtp_1
Xhold388 lsu.load_fifo.queue\[7\]\[14\] VGND VGND VPWR VPWR net856 sky130_fd_sc_hd__dlygate4sd3_1
X_3418_ net289 net751 _2058_ VGND VGND VPWR VPWR _1067_ sky130_fd_sc_hd__mux2_1
X_3349_ net611 net293 net174 VGND VGND VPWR VPWR _0959_ sky130_fd_sc_hd__mux2_1
XFILLER_97_181 VPWR VGND VPWR VGND sky130_ef_sc_hd__decap_12
XFILLER_73_505 VPWR VGND VPWR VGND sky130_ef_sc_hd__decap_12
X_5019_ clknet_leaf_49_clk _1074_ VGND VGND VPWR VPWR lsu.store_fifo.queue\[13\]\[8\]
+ sky130_fd_sc_hd__dfxtp_1
XFILLER_26_67 VGND VGND VPWR VPWR sky130_fd_sc_hd__fill_1
XFILLER_26_498 VPWR VGND VPWR VGND sky130_ef_sc_hd__decap_12
XFILLER_41_402 VGND VGND VPWR VPWR sky130_fd_sc_hd__decap_4
XFILLER_42_11 VGND VGND VPWR VPWR sky130_fd_sc_hd__fill_1
XTAP_TAPCELL_ROW_11_349 VGND VPWR sky130_fd_sc_hd__tapvpwrvgnd_1
XFILLER_42_99 VPWR VGND VPWR VGND sky130_ef_sc_hd__decap_12
XFILLER_1_553 VGND VGND VPWR VPWR sky130_fd_sc_hd__decap_6
XFILLER_3_27 VPWR VGND VPWR VGND sky130_ef_sc_hd__decap_12
XFILLER_49_513 VGND VGND VPWR VPWR sky130_fd_sc_hd__fill_1
XFILLER_1_597 VPWR VGND VPWR VGND sky130_ef_sc_hd__decap_12
XFILLER_76_376 VGND VGND VPWR VPWR sky130_fd_sc_hd__fill_1
XTAP_TAPCELL_ROW_19_438 VGND VPWR sky130_fd_sc_hd__tapvpwrvgnd_1
XFILLER_36_229 VGND VGND VPWR VPWR sky130_fd_sc_hd__fill_1
XTAP_TAPCELL_ROW_47_747 VGND VPWR sky130_fd_sc_hd__tapvpwrvgnd_1
XPHY_EDGE_ROW_103_Left_210 VGND VGND VPWR VPWR sky130_fd_sc_hd__decap_3
XFILLER_83_95 VGND VGND VPWR VPWR sky130_fd_sc_hd__fill_1
XFILLER_32_413 VGND VGND VPWR VPWR sky130_fd_sc_hd__decap_6
XTAP_TAPCELL_ROW_106_1399 VGND VPWR sky130_fd_sc_hd__tapvpwrvgnd_1
X_2720_ net523 net287 _2025_ VGND VGND VPWR VPWR _0241_ sky130_fd_sc_hd__mux2_1
Xlsu_wrapper_452 VGND VGND VPWR VPWR lsu_wrapper_452/HI store_data[15] sky130_fd_sc_hd__conb_1
Xlsu_wrapper_463 VGND VGND VPWR VPWR lsu_wrapper_463/HI store_data[26] sky130_fd_sc_hd__conb_1
XFILLER_8_141 VGND VGND VPWR VPWR sky130_fd_sc_hd__decap_4
X_2651_ net289 net1085 _2019_ VGND VGND VPWR VPWR _0178_ sky130_fd_sc_hd__mux2_1
X_2582_ _1547_ _1924_ _1972_ _1973_ VGND VGND VPWR VPWR _1974_ sky130_fd_sc_hd__a31o_1
XFILLER_59_3 VGND VGND VPWR VPWR sky130_fd_sc_hd__fill_2
XTAP_TAPCELL_ROW_74_1045 VGND VPWR sky130_fd_sc_hd__tapvpwrvgnd_1
X_4321_ clknet_leaf_78_clk _0378_ VGND VGND VPWR VPWR lsu.load_fifo.queue\[10\]\[27\]
+ sky130_fd_sc_hd__dfxtp_1
X_4252_ clknet_leaf_53_clk _0309_ VGND VGND VPWR VPWR lsu.store_fifo.queue\[1\]\[0\]
+ sky130_fd_sc_hd__dfxtp_1
XFILLER_101_418 VPWR VGND VPWR VGND sky130_ef_sc_hd__decap_12
X_3203_ net980 net293 net203 VGND VGND VPWR VPWR _0704_ sky130_fd_sc_hd__mux2_1
X_4183_ clknet_leaf_64_clk _0240_ VGND VGND VPWR VPWR lsu.store_fifo.queue\[8\]\[1\]
+ sky130_fd_sc_hd__dfxtp_1
X_3134_ net579 net298 net183 VGND VGND VPWR VPWR _0637_ sky130_fd_sc_hd__mux2_1
XFILLER_103_39 VPWR VGND VPWR VGND sky130_ef_sc_hd__decap_12
X_3065_ net921 net305 net207 VGND VGND VPWR VPWR _0570_ sky130_fd_sc_hd__mux2_1
XFILLER_55_549 VGND VGND VPWR VPWR sky130_fd_sc_hd__decap_8
XTAP_TAPCELL_ROW_85_1163 VGND VPWR sky130_fd_sc_hd__tapvpwrvgnd_1
X_3967_ net1261 _1412_ net253 VGND VGND VPWR VPWR _1007_ sky130_fd_sc_hd__mux2_1
X_2918_ net1016 net328 net218 VGND VGND VPWR VPWR _0430_ sky130_fd_sc_hd__mux2_1
Xclkbuf_leaf_30_clk clknet_3_3__leaf_clk VGND VGND VPWR VPWR clknet_leaf_30_clk sky130_fd_sc_hd__clkbuf_8
X_3898_ lsu.load_fifo.queue\[4\]\[14\] lsu.load_fifo.queue\[5\]\[14\] lsu.load_fifo.queue\[6\]\[14\]
+ lsu.load_fifo.queue\[7\]\[14\] net385 net368 VGND VGND VPWR VPWR _1353_ sky130_fd_sc_hd__mux4_1
X_2849_ net982 net337 net222 VGND VGND VPWR VPWR _0360_ sky130_fd_sc_hd__mux2_1
XTAP_TAPCELL_ROW_96_1281 VGND VPWR sky130_fd_sc_hd__tapvpwrvgnd_1
XFILLER_88_29 VPWR VGND VPWR VGND sky130_ef_sc_hd__decap_12
Xhold130 lsu.load_fifo.queue\[4\]\[27\] VGND VGND VPWR VPWR net598 sky130_fd_sc_hd__dlygate4sd3_1
Xhold141 lsu.load_fifo.queue\[0\]\[11\] VGND VGND VPWR VPWR net609 sky130_fd_sc_hd__dlygate4sd3_1
XFILLER_2_306 VGND VGND VPWR VPWR sky130_fd_sc_hd__fill_2
X_4519_ clknet_leaf_76_clk _0576_ VGND VGND VPWR VPWR lsu.load_fifo.queue\[2\]\[31\]
+ sky130_fd_sc_hd__dfxtp_1
Xhold152 lsu.store_fifo.queue\[12\]\[3\] VGND VGND VPWR VPWR net620 sky130_fd_sc_hd__dlygate4sd3_1
Xhold174 lsu.load_fifo.queue\[11\]\[10\] VGND VGND VPWR VPWR net642 sky130_fd_sc_hd__dlygate4sd3_1
Xhold163 lsu.load_fifo.queue\[3\]\[29\] VGND VGND VPWR VPWR net631 sky130_fd_sc_hd__dlygate4sd3_1
Xhold185 lsu.load_fifo.queue\[14\]\[28\] VGND VGND VPWR VPWR net653 sky130_fd_sc_hd__dlygate4sd3_1
XFILLER_104_278 VGND VGND VPWR VPWR sky130_fd_sc_hd__fill_1
Xhold196 lsu.store_fifo.queue\[15\]\[0\] VGND VGND VPWR VPWR net664 sky130_fd_sc_hd__dlygate4sd3_1
XFILLER_58_343 VGND VGND VPWR VPWR sky130_fd_sc_hd__decap_4
XTAP_TAPCELL_ROW_16_408 VGND VPWR sky130_fd_sc_hd__tapvpwrvgnd_1
XFILLER_26_262 VGND VGND VPWR VPWR sky130_fd_sc_hd__decap_4
XTAP_TAPCELL_ROW_44_717 VGND VPWR sky130_fd_sc_hd__tapvpwrvgnd_1
XFILLER_14_457 VPWR VGND VPWR VGND sky130_ef_sc_hd__decap_12
XTAP_TAPCELL_ROW_24_496 VGND VPWR sky130_fd_sc_hd__tapvpwrvgnd_1
XFILLER_41_276 VGND VGND VPWR VPWR sky130_fd_sc_hd__decap_4
Xclkbuf_leaf_21_clk clknet_3_2__leaf_clk VGND VGND VPWR VPWR clknet_leaf_21_clk sky130_fd_sc_hd__clkbuf_8
XFILLER_6_601 VPWR VGND VPWR VGND sky130_ef_sc_hd__decap_12
XFILLER_1_361 VPWR VGND VPWR VGND sky130_ef_sc_hd__decap_12
XFILLER_94_83 VGND VGND VPWR VPWR sky130_fd_sc_hd__fill_1
X_4870_ clknet_leaf_42_clk _0925_ _0120_ VGND VGND VPWR VPWR lsu.load_counter\[20\]
+ sky130_fd_sc_hd__dfrtp_2
X_3821_ net1258 _1287_ net254 VGND VGND VPWR VPWR _1028_ sky130_fd_sc_hd__mux2_1
XFILLER_32_298 VGND VGND VPWR VPWR sky130_fd_sc_hd__decap_8
XFILLER_9_461 VPWR VGND VPWR VGND sky130_ef_sc_hd__decap_12
X_3752_ _1163_ _1231_ VGND VGND VPWR VPWR _1233_ sky130_fd_sc_hd__or2_1
Xclkbuf_leaf_12_clk clknet_3_3__leaf_clk VGND VGND VPWR VPWR clknet_leaf_12_clk sky130_fd_sc_hd__clkbuf_8
X_3683_ acc.byte3\[6\] acc.byte2\[6\] VGND VGND VPWR VPWR _1165_ sky130_fd_sc_hd__nand2_1
X_2703_ net578 net295 net233 VGND VGND VPWR VPWR _0227_ sky130_fd_sc_hd__mux2_1
X_2634_ _1115_ _1440_ _1446_ _2009_ lsu.store_fifo.r_en VGND VGND VPWR VPWR _2010_
+ sky130_fd_sc_hd__a2111o_1
X_2565_ lsu.current_load_addr\[10\] _1925_ lsu.current_load_addr\[11\] VGND VGND VPWR
+ VPWR _1961_ sky130_fd_sc_hd__a21o_1
XFILLER_99_210 VGND VGND VPWR VPWR sky130_fd_sc_hd__decap_4
XFILLER_99_254 VGND VGND VPWR VPWR sky130_fd_sc_hd__decap_8
X_4304_ clknet_leaf_24_clk _0361_ VGND VGND VPWR VPWR lsu.load_fifo.queue\[10\]\[10\]
+ sky130_fd_sc_hd__dfxtp_1
X_2496_ net1291 _1837_ _1838_ VGND VGND VPWR VPWR _0788_ sky130_fd_sc_hd__o21a_1
XFILLER_87_449 VPWR VGND VPWR VGND sky130_ef_sc_hd__decap_12
X_4235_ clknet_leaf_70_clk _0292_ VGND VGND VPWR VPWR lsu.store_fifo.queue\[3\]\[3\]
+ sky130_fd_sc_hd__dfxtp_1
Xclkbuf_leaf_79_clk clknet_3_1__leaf_clk VGND VGND VPWR VPWR clknet_leaf_79_clk sky130_fd_sc_hd__clkbuf_8
X_4166_ clknet_leaf_17_clk _0223_ VGND VGND VPWR VPWR lsu.load_fifo.queue\[11\]\[26\]
+ sky130_fd_sc_hd__dfxtp_1
XFILLER_95_482 VGND VGND VPWR VPWR sky130_fd_sc_hd__fill_2
X_3117_ net609 net332 net181 VGND VGND VPWR VPWR _0620_ sky130_fd_sc_hd__mux2_1
X_4097_ net400 _1528_ VGND VGND VPWR VPWR _1529_ sky130_fd_sc_hd__nor2_1
XFILLER_55_335 VGND VGND VPWR VPWR sky130_fd_sc_hd__fill_1
X_3048_ net530 net339 net209 VGND VGND VPWR VPWR _0553_ sky130_fd_sc_hd__mux2_1
XFILLER_11_405 VPWR VGND VPWR VGND sky130_ef_sc_hd__decap_12
XFILLER_23_243 VGND VGND VPWR VPWR sky130_fd_sc_hd__fill_1
X_4999_ clknet_leaf_84_clk _1054_ VGND VGND VPWR VPWR lsu.load_fifo.queue\[14\]\[20\]
+ sky130_fd_sc_hd__dfxtp_1
XTAP_TAPCELL_ROW_98_1310 VGND VPWR sky130_fd_sc_hd__tapvpwrvgnd_1
XFILLER_11_449 VPWR VGND VPWR VGND sky130_ef_sc_hd__decap_12
XFILLER_23_57 VGND VGND VPWR VPWR sky130_fd_sc_hd__decap_4
XTAP_TAPCELL_ROW_21_466 VGND VPWR sky130_fd_sc_hd__tapvpwrvgnd_1
XFILLER_3_615 VGND VGND VPWR VPWR sky130_fd_sc_hd__fill_1
XFILLER_105_543 VGND VGND VPWR VPWR sky130_fd_sc_hd__decap_4
Xfanout440 net442 VGND VGND VPWR VPWR net440 sky130_fd_sc_hd__buf_4
XFILLER_48_21 VGND VGND VPWR VPWR sky130_fd_sc_hd__decap_6
XFILLER_86_460 VGND VGND VPWR VPWR sky130_fd_sc_hd__fill_2
XFILLER_19_505 VPWR VGND VPWR VGND sky130_ef_sc_hd__decap_12
XFILLER_58_173 VGND VGND VPWR VPWR sky130_fd_sc_hd__fill_1
XTAP_TAPCELL_ROW_29_544 VGND VPWR sky130_fd_sc_hd__tapvpwrvgnd_1
XTAP_TAPCELL_ROW_57_853 VGND VPWR sky130_fd_sc_hd__tapvpwrvgnd_1
XTAP_TAPCELL_ROW_103_1358 VGND VPWR sky130_fd_sc_hd__tapvpwrvgnd_1
XFILLER_6_475 VGND VGND VPWR VPWR sky130_fd_sc_hd__fill_1
X_2350_ lsu.store_counter\[14\] net470 _1587_ VGND VGND VPWR VPWR _1789_ sky130_fd_sc_hd__and3_1
XTAP_TAPCELL_ROW_71_1015 VGND VPWR sky130_fd_sc_hd__tapvpwrvgnd_1
X_2281_ _1740_ _1742_ VGND VGND VPWR VPWR _0899_ sky130_fd_sc_hd__and2_1
XFILLER_69_449 VPWR VGND VPWR VGND sky130_ef_sc_hd__decap_12
Xclkbuf_leaf_1_clk clknet_3_0__leaf_clk VGND VGND VPWR VPWR clknet_leaf_1_clk sky130_fd_sc_hd__clkbuf_8
X_4020_ net401 _1458_ VGND VGND VPWR VPWR _1459_ sky130_fd_sc_hd__nor2_1
XFILLER_92_430 VGND VGND VPWR VPWR sky130_fd_sc_hd__fill_1
XFILLER_92_474 VGND VGND VPWR VPWR sky130_fd_sc_hd__fill_2
X_4922_ clknet_leaf_69_clk _0977_ VGND VGND VPWR VPWR lsu.load_fifo.queue\[13\]\[17\]
+ sky130_fd_sc_hd__dfxtp_1
XFILLER_100_18 VGND VGND VPWR VPWR sky130_fd_sc_hd__decap_8
XTAP_TAPCELL_ROW_82_1133 VGND VPWR sky130_fd_sc_hd__tapvpwrvgnd_1
XFILLER_100_29 VPWR VGND VPWR VGND sky130_ef_sc_hd__decap_12
X_4853_ clknet_leaf_39_clk _0908_ _0103_ VGND VGND VPWR VPWR lsu.load_counter\[3\]
+ sky130_fd_sc_hd__dfrtp_1
XFILLER_20_235 VGND VGND VPWR VPWR sky130_fd_sc_hd__fill_1
X_4784_ clknet_leaf_57_clk _0841_ VGND VGND VPWR VPWR lsu.store_fifo.queue\[0\]\[4\]
+ sky130_fd_sc_hd__dfxtp_1
X_3804_ lsu.load_fifo.queue\[12\]\[28\] lsu.load_fifo.queue\[13\]\[28\] lsu.load_fifo.queue\[14\]\[28\]
+ lsu.load_fifo.queue\[15\]\[28\] net392 net375 VGND VGND VPWR VPWR _1273_ sky130_fd_sc_hd__mux4_1
X_3735_ acc.byte1\[0\] acc.byte0\[0\] VGND VGND VPWR VPWR _1217_ sky130_fd_sc_hd__nor2_1
Xclkload61 clknet_leaf_61_clk VGND VGND VPWR VPWR clkload61/Y sky130_fd_sc_hd__clkinv_2
X_3666_ _1145_ _1146_ _1140_ VGND VGND VPWR VPWR _1148_ sky130_fd_sc_hd__a21o_1
Xclkload50 clknet_leaf_55_clk VGND VGND VPWR VPWR clkload50/Y sky130_fd_sc_hd__clkinv_8
Xclkload72 clknet_leaf_39_clk VGND VGND VPWR VPWR clkload72/Y sky130_fd_sc_hd__inv_6
XTAP_TAPCELL_ROW_93_1251 VGND VPWR sky130_fd_sc_hd__tapvpwrvgnd_1
X_2617_ lsu.load_fifo.w_ptr\[0\] _1996_ VGND VGND VPWR VPWR _1997_ sky130_fd_sc_hd__nand2_1
Xclkload83 clknet_leaf_47_clk VGND VGND VPWR VPWR clkload83/Y sky130_fd_sc_hd__inv_6
X_3597_ net423 VGND VGND VPWR VPWR _0161_ sky130_fd_sc_hd__inv_2
X_2548_ lsu.current_load_addr\[16\] _1948_ net477 VGND VGND VPWR VPWR _0743_ sky130_fd_sc_hd__mux2_4
XFILLER_0_629 VGND VGND VPWR VPWR sky130_fd_sc_hd__fill_1
X_2479_ net97 net265 VGND VGND VPWR VPWR _1899_ sky130_fd_sc_hd__nand2_1
X_4218_ clknet_leaf_54_clk _0275_ VGND VGND VPWR VPWR lsu.store_fifo.queue\[5\]\[6\]
+ sky130_fd_sc_hd__dfxtp_1
X_4149_ clknet_leaf_83_clk _0206_ VGND VGND VPWR VPWR lsu.load_fifo.queue\[11\]\[9\]
+ sky130_fd_sc_hd__dfxtp_1
XFILLER_18_46 VGND VGND VPWR VPWR sky130_fd_sc_hd__fill_1
XFILLER_55_110 VGND VGND VPWR VPWR sky130_fd_sc_hd__fill_2
XFILLER_83_474 VPWR VGND VPWR VGND sky130_ef_sc_hd__decap_12
XFILLER_70_113 VGND VGND VPWR VPWR sky130_fd_sc_hd__fill_1
XTAP_TAPCELL_ROW_26_514 VGND VPWR sky130_fd_sc_hd__tapvpwrvgnd_1
XFILLER_43_327 VGND VGND VPWR VPWR sky130_fd_sc_hd__decap_8
XTAP_TAPCELL_ROW_54_823 VGND VPWR sky130_fd_sc_hd__tapvpwrvgnd_1
XFILLER_70_179 VGND VGND VPWR VPWR sky130_fd_sc_hd__decap_4
XFILLER_51_393 VGND VGND VPWR VPWR sky130_fd_sc_hd__decap_4
XFILLER_7_217 VGND VGND VPWR VPWR sky130_fd_sc_hd__decap_6
Xclkload0 clknet_3_0__leaf_clk VGND VGND VPWR VPWR clkload0/X sky130_fd_sc_hd__clkbuf_8
XFILLER_50_99 VGND VGND VPWR VPWR sky130_fd_sc_hd__fill_1
XFILLER_93_205 VPWR VGND VPWR VGND sky130_ef_sc_hd__decap_12
XTAP_TAPCELL_ROW_6_294 VGND VPWR sky130_fd_sc_hd__tapvpwrvgnd_1
Xfanout292 lsu.load_fifo.data_in\[31\] VGND VGND VPWR VPWR net292 sky130_fd_sc_hd__clkbuf_2
Xfanout270 net271 VGND VGND VPWR VPWR net270 sky130_fd_sc_hd__buf_2
Xfanout281 acc.data_out\[5\] VGND VGND VPWR VPWR net281 sky130_fd_sc_hd__clkbuf_2
XFILLER_101_590 VPWR VGND VPWR VGND sky130_ef_sc_hd__decap_12
XFILLER_93_249 VPWR VGND VPWR VGND sky130_ef_sc_hd__decap_12
XFILLER_61_113 VGND VGND VPWR VPWR sky130_fd_sc_hd__fill_1
XFILLER_91_51 VGND VGND VPWR VPWR sky130_fd_sc_hd__decap_4
XFILLER_15_541 VPWR VGND VPWR VGND sky130_ef_sc_hd__decap_12
XFILLER_15_585 VPWR VGND VPWR VGND sky130_ef_sc_hd__decap_12
X_3520_ net439 VGND VGND VPWR VPWR _0084_ sky130_fd_sc_hd__inv_2
Xhold718 lsu.load_fifo.queue\[13\]\[24\] VGND VGND VPWR VPWR net1186 sky130_fd_sc_hd__dlygate4sd3_1
Xhold707 lsu.store_fifo.queue\[3\]\[3\] VGND VGND VPWR VPWR net1175 sky130_fd_sc_hd__dlygate4sd3_1
XFILLER_6_294 VGND VGND VPWR VPWR sky130_fd_sc_hd__decap_3
Xhold729 _0821_ VGND VGND VPWR VPWR net1197 sky130_fd_sc_hd__dlygate4sd3_1
X_3451_ net432 VGND VGND VPWR VPWR _0015_ sky130_fd_sc_hd__inv_2
X_2402_ net1239 _1721_ _1838_ VGND VGND VPWR VPWR _0833_ sky130_fd_sc_hd__a21bo_1
X_3382_ net293 net1166 net170 VGND VGND VPWR VPWR _0991_ sky130_fd_sc_hd__mux2_1
XFILLER_41_3 VGND VGND VPWR VPWR sky130_fd_sc_hd__decap_6
XFILLER_97_544 VGND VGND VPWR VPWR sky130_fd_sc_hd__fill_1
X_2333_ lsu.load_fifo.w_en lsu.load_fifo.r_en VGND VGND VPWR VPWR _1773_ sky130_fd_sc_hd__or2_1
XFILLER_97_588 VGND VGND VPWR VPWR sky130_fd_sc_hd__decap_8
X_2264_ lsu.store_counter\[9\] lsu.store_counter\[8\] _1728_ VGND VGND VPWR VPWR _1729_
+ sky130_fd_sc_hd__and3_1
X_2195_ _1097_ _1681_ _1682_ net160 VGND VGND VPWR VPWR _0925_ sky130_fd_sc_hd__a2bb2o_4
X_4003_ net420 net409 VGND VGND VPWR VPWR _1443_ sky130_fd_sc_hd__nand2b_1
XFILLER_1_93 VGND VGND VPWR VPWR sky130_fd_sc_hd__fill_1
XFILLER_52_157 VGND VGND VPWR VPWR sky130_fd_sc_hd__fill_2
X_4905_ clknet_leaf_35_clk _0960_ VGND VGND VPWR VPWR lsu.load_fifo.queue\[13\]\[0\]
+ sky130_fd_sc_hd__dfxtp_1
X_4836_ clknet_leaf_45_clk _0893_ _0086_ VGND VGND VPWR VPWR lsu.store_counter\[13\]
+ sky130_fd_sc_hd__dfrtp_1
XFILLER_33_393 VGND VGND VPWR VPWR sky130_fd_sc_hd__decap_6
X_4767_ clknet_leaf_47_clk _0824_ VGND VGND VPWR VPWR net131 sky130_fd_sc_hd__dfxtp_1
XTAP_TAPCELL_ROW_31_572 VGND VPWR sky130_fd_sc_hd__tapvpwrvgnd_1
X_4698_ clknet_leaf_61_clk _0755_ VGND VGND VPWR VPWR lsu.store_fifo.queue\[14\]\[2\]
+ sky130_fd_sc_hd__dfxtp_1
X_3718_ _1198_ _1199_ VGND VGND VPWR VPWR _1200_ sky130_fd_sc_hd__nand2_1
X_3649_ acc.byte1\[6\] acc.byte0\[6\] VGND VGND VPWR VPWR _1131_ sky130_fd_sc_hd__or2_1
XFILLER_96_29 VPWR VGND VPWR VGND sky130_ef_sc_hd__decap_12
XFILLER_88_533 VPWR VGND VPWR VGND sky130_ef_sc_hd__decap_12
XFILLER_29_34 VGND VGND VPWR VPWR sky130_fd_sc_hd__decap_4
XFILLER_102_365 VGND VGND VPWR VPWR sky130_fd_sc_hd__fill_2
Xhold34 lsu.load_fifo.queue\[0\]\[29\] VGND VGND VPWR VPWR net502 sky130_fd_sc_hd__dlygate4sd3_1
Xhold45 lsu.load_fifo.queue\[0\]\[2\] VGND VGND VPWR VPWR net513 sky130_fd_sc_hd__dlygate4sd3_1
Xhold56 lsu.store_fifo.queue\[14\]\[3\] VGND VGND VPWR VPWR net524 sky130_fd_sc_hd__dlygate4sd3_1
Xhold89 net114 VGND VGND VPWR VPWR net557 sky130_fd_sc_hd__dlygate4sd3_1
Xhold67 lsu.load_fifo.queue\[2\]\[28\] VGND VGND VPWR VPWR net535 sky130_fd_sc_hd__dlygate4sd3_1
Xhold78 lsu.load_fifo.queue\[2\]\[0\] VGND VGND VPWR VPWR net546 sky130_fd_sc_hd__dlygate4sd3_1
XTAP_TAPCELL_ROW_67_970 VGND VPWR sky130_fd_sc_hd__tapvpwrvgnd_1
XTAP_TAPCELL_ROW_3_264 VGND VPWR sky130_fd_sc_hd__tapvpwrvgnd_1
XTAP_TAPCELL_ROW_39_661 VGND VPWR sky130_fd_sc_hd__tapvpwrvgnd_1
XFILLER_71_422 VPWR VGND VPWR VGND sky130_ef_sc_hd__decap_12
XTAP_TAPCELL_ROW_100_1328 VGND VPWR sky130_fd_sc_hd__tapvpwrvgnd_1
XFILLER_12_533 VPWR VGND VPWR VGND sky130_ef_sc_hd__decap_12
XFILLER_61_32 VGND VGND VPWR VPWR sky130_fd_sc_hd__decap_6
XFILLER_6_27 VGND VGND VPWR VPWR sky130_fd_sc_hd__fill_1
XANTENNA_9 _2057_ VGND VGND VPWR VPWR sky130_fd_sc_hd__diode_2
XFILLER_10_80 VGND VGND VPWR VPWR sky130_fd_sc_hd__decap_4
XFILLER_86_62 VGND VGND VPWR VPWR sky130_fd_sc_hd__fill_2
XFILLER_66_205 VGND VGND VPWR VPWR sky130_fd_sc_hd__decap_3
XFILLER_66_216 VGND VGND VPWR VPWR sky130_fd_sc_hd__decap_3
XFILLER_66_227 VPWR VGND VPWR VGND sky130_ef_sc_hd__decap_12
XFILLER_47_441 VGND VGND VPWR VPWR sky130_fd_sc_hd__decap_6
X_2951_ net328 net1111 net214 VGND VGND VPWR VPWR _0462_ sky130_fd_sc_hd__mux2_1
XFILLER_62_477 VGND VGND VPWR VPWR sky130_fd_sc_hd__decap_3
XFILLER_89_3 VPWR VGND VPWR VGND sky130_ef_sc_hd__decap_12
X_2882_ net514 net334 net195 VGND VGND VPWR VPWR _0393_ sky130_fd_sc_hd__mux2_1
XFILLER_30_341 VGND VGND VPWR VPWR sky130_fd_sc_hd__decap_4
X_4621_ clknet_leaf_5_clk _0678_ VGND VGND VPWR VPWR lsu.load_fifo.queue\[15\]\[5\]
+ sky130_fd_sc_hd__dfxtp_1
X_4552_ clknet_leaf_34_clk _0609_ VGND VGND VPWR VPWR lsu.load_fifo.queue\[0\]\[0\]
+ sky130_fd_sc_hd__dfxtp_1
X_3503_ net444 VGND VGND VPWR VPWR _0067_ sky130_fd_sc_hd__inv_2
Xhold504 lsu.load_fifo.queue\[7\]\[3\] VGND VGND VPWR VPWR net972 sky130_fd_sc_hd__dlygate4sd3_1
X_4483_ clknet_leaf_81_clk _0540_ VGND VGND VPWR VPWR lsu.load_fifo.queue\[3\]\[27\]
+ sky130_fd_sc_hd__dfxtp_1
Xhold526 lsu.load_fifo.queue\[5\]\[27\] VGND VGND VPWR VPWR net994 sky130_fd_sc_hd__dlygate4sd3_1
Xhold515 lsu.store_fifo.queue\[5\]\[1\] VGND VGND VPWR VPWR net983 sky130_fd_sc_hd__dlygate4sd3_1
XTAP_TAPCELL_ROW_77_1076 VGND VPWR sky130_fd_sc_hd__tapvpwrvgnd_1
Xhold548 lsu.load_fifo.queue\[6\]\[13\] VGND VGND VPWR VPWR net1016 sky130_fd_sc_hd__dlygate4sd3_1
Xhold559 lsu.store_fifo.queue\[4\]\[8\] VGND VGND VPWR VPWR net1027 sky130_fd_sc_hd__dlygate4sd3_1
X_3434_ net861 net278 _2059_ VGND VGND VPWR VPWR _1092_ sky130_fd_sc_hd__mux2_1
Xhold537 lsu.load_fifo.queue\[1\]\[8\] VGND VGND VPWR VPWR net1005 sky130_fd_sc_hd__dlygate4sd3_1
XTAP_TAPCELL_ROW_90_1221 VGND VPWR sky130_fd_sc_hd__tapvpwrvgnd_1
X_3365_ net326 net1174 net169 VGND VGND VPWR VPWR _0974_ sky130_fd_sc_hd__mux2_1
X_2316_ _1761_ _1763_ VGND VGND VPWR VPWR _0885_ sky130_fd_sc_hd__and2_1
X_3296_ net332 net49 net248 VGND VGND VPWR VPWR _0858_ sky130_fd_sc_hd__mux2_1
XFILLER_85_558 VGND VGND VPWR VPWR sky130_fd_sc_hd__fill_2
XFILLER_85_536 VGND VGND VPWR VPWR sky130_fd_sc_hd__fill_2
X_2247_ _1106_ _1258_ _1712_ VGND VGND VPWR VPWR _0903_ sky130_fd_sc_hd__and3_1
XFILLER_38_430 VGND VGND VPWR VPWR sky130_fd_sc_hd__decap_6
X_5035_ clknet_leaf_61_clk _1090_ VGND VGND VPWR VPWR lsu.store_fifo.queue\[12\]\[4\]
+ sky130_fd_sc_hd__dfxtp_1
X_2178_ lsu.load_counter\[3\] _1667_ VGND VGND VPWR VPWR _1668_ sky130_fd_sc_hd__and2_1
XTAP_TAPCELL_ROW_0_223 VGND VPWR sky130_fd_sc_hd__tapvpwrvgnd_1
XTAP_TAPCELL_ROW_0_234 VGND VPWR sky130_fd_sc_hd__tapvpwrvgnd_1
XFILLER_38_485 VGND VGND VPWR VPWR sky130_fd_sc_hd__decap_6
XTAP_TAPCELL_ROW_88_1194 VGND VPWR sky130_fd_sc_hd__tapvpwrvgnd_1
XFILLER_80_230 VGND VGND VPWR VPWR sky130_fd_sc_hd__decap_4
XTAP_TAPCELL_ROW_36_631 VGND VPWR sky130_fd_sc_hd__tapvpwrvgnd_1
XFILLER_80_274 VGND VGND VPWR VPWR sky130_fd_sc_hd__decap_8
XFILLER_21_363 VGND VGND VPWR VPWR sky130_fd_sc_hd__fill_1
X_4819_ clknet_leaf_26_clk _0876_ VGND VGND VPWR VPWR lsu.load_fifo.data_in\[29\]
+ sky130_fd_sc_hd__dfxtp_1
XFILLER_5_529 VPWR VGND VPWR VGND sky130_ef_sc_hd__decap_12
XFILLER_31_57 VGND VGND VPWR VPWR sky130_fd_sc_hd__decap_4
XTAP_TAPCELL_ROW_8_323 VGND VPWR sky130_fd_sc_hd__tapvpwrvgnd_1
Xinput102 store_complete VGND VGND VPWR VPWR net102 sky130_fd_sc_hd__clkbuf_2
XFILLER_0_245 VGND VGND VPWR VPWR sky130_fd_sc_hd__decap_3
XFILLER_88_363 VGND VGND VPWR VPWR sky130_fd_sc_hd__fill_1
XFILLER_84_580 VGND VGND VPWR VPWR sky130_fd_sc_hd__decap_8
XFILLER_56_282 VGND VGND VPWR VPWR sky130_fd_sc_hd__fill_1
XPHY_EDGE_ROW_19_Right_19 VGND VGND VPWR VPWR sky130_fd_sc_hd__decap_3
XFILLER_71_252 VPWR VGND VPWR VGND sky130_ef_sc_hd__decap_12
XFILLER_32_628 VGND VGND VPWR VPWR sky130_fd_sc_hd__fill_2
XTAP_TAPCELL_ROW_70_998 VGND VPWR sky130_fd_sc_hd__tapvpwrvgnd_1
XFILLER_12_363 VGND VGND VPWR VPWR sky130_fd_sc_hd__fill_1
XTAP_TAPCELL_ROW_42_689 VGND VPWR sky130_fd_sc_hd__tapvpwrvgnd_1
Xclkbuf_3_1__f_clk clknet_0_clk VGND VGND VPWR VPWR clknet_3_1__leaf_clk sky130_fd_sc_hd__clkbuf_16
XPHY_EDGE_ROW_28_Right_28 VGND VGND VPWR VPWR sky130_fd_sc_hd__decap_3
XFILLER_98_138 VGND VGND VPWR VPWR sky130_fd_sc_hd__fill_2
X_3150_ net913 net333 net177 VGND VGND VPWR VPWR _0652_ sky130_fd_sc_hd__mux2_1
X_2101_ net5 _1560_ VGND VGND VPWR VPWR _1591_ sky130_fd_sc_hd__xnor2_2
XFILLER_94_333 VPWR VGND VPWR VGND sky130_ef_sc_hd__decap_12
X_3081_ net338 net1005 net188 VGND VGND VPWR VPWR _0585_ sky130_fd_sc_hd__mux2_1
XFILLER_67_569 VPWR VGND VPWR VGND sky130_ef_sc_hd__decap_12
XPHY_EDGE_ROW_37_Right_37 VGND VGND VPWR VPWR sky130_fd_sc_hd__decap_3
XFILLER_47_271 VGND VGND VPWR VPWR sky130_fd_sc_hd__decap_8
XFILLER_23_617 VPWR VGND VPWR VGND sky130_ef_sc_hd__decap_12
XFILLER_50_414 VGND VGND VPWR VPWR sky130_fd_sc_hd__decap_6
X_3983_ lsu.load_fifo.queue\[0\]\[2\] lsu.load_fifo.queue\[1\]\[2\] lsu.load_fifo.queue\[2\]\[2\]
+ lsu.load_fifo.queue\[3\]\[2\] net393 net376 VGND VGND VPWR VPWR _1426_ sky130_fd_sc_hd__mux4_1
X_2934_ net911 net296 net220 VGND VGND VPWR VPWR _0446_ sky130_fd_sc_hd__mux2_1
X_2865_ net848 net304 net223 VGND VGND VPWR VPWR _0376_ sky130_fd_sc_hd__mux2_1
X_4604_ clknet_leaf_83_clk _0661_ VGND VGND VPWR VPWR lsu.load_fifo.queue\[8\]\[20\]
+ sky130_fd_sc_hd__dfxtp_1
XPHY_EDGE_ROW_46_Right_46 VGND VGND VPWR VPWR sky130_fd_sc_hd__decap_3
X_2796_ net288 net996 _2032_ VGND VGND VPWR VPWR _0310_ sky130_fd_sc_hd__mux2_1
X_4535_ clknet_leaf_11_clk _0592_ VGND VGND VPWR VPWR lsu.load_fifo.queue\[1\]\[15\]
+ sky130_fd_sc_hd__dfxtp_1
Xhold301 lsu.load_fifo.queue\[8\]\[5\] VGND VGND VPWR VPWR net769 sky130_fd_sc_hd__dlygate4sd3_1
Xhold334 net110 VGND VGND VPWR VPWR net802 sky130_fd_sc_hd__dlygate4sd3_1
Xhold323 lsu.load_fifo.queue\[5\]\[28\] VGND VGND VPWR VPWR net791 sky130_fd_sc_hd__dlygate4sd3_1
Xhold312 lsu.load_fifo.queue\[8\]\[17\] VGND VGND VPWR VPWR net780 sky130_fd_sc_hd__dlygate4sd3_1
XFILLER_89_105 VGND VGND VPWR VPWR sky130_fd_sc_hd__decap_6
X_4466_ clknet_leaf_24_clk _0523_ VGND VGND VPWR VPWR lsu.load_fifo.queue\[3\]\[10\]
+ sky130_fd_sc_hd__dfxtp_1
Xhold378 lsu.load_fifo.queue\[2\]\[11\] VGND VGND VPWR VPWR net846 sky130_fd_sc_hd__dlygate4sd3_1
Xhold356 lsu.store_fifo.queue\[12\]\[4\] VGND VGND VPWR VPWR net824 sky130_fd_sc_hd__dlygate4sd3_1
Xhold367 lsu.load_fifo.queue\[8\]\[15\] VGND VGND VPWR VPWR net835 sky130_fd_sc_hd__dlygate4sd3_1
Xhold345 lsu.load_fifo.queue\[7\]\[0\] VGND VGND VPWR VPWR net813 sky130_fd_sc_hd__dlygate4sd3_1
X_4397_ clknet_leaf_4_clk _0454_ VGND VGND VPWR VPWR lsu.load_fifo.queue\[5\]\[5\]
+ sky130_fd_sc_hd__dfxtp_1
Xhold389 lsu.load_fifo.queue\[0\]\[26\] VGND VGND VPWR VPWR net857 sky130_fd_sc_hd__dlygate4sd3_1
X_3417_ net291 net1136 _2058_ VGND VGND VPWR VPWR _1066_ sky130_fd_sc_hd__mux2_1
X_3348_ net716 net294 net175 VGND VGND VPWR VPWR _0958_ sky130_fd_sc_hd__mux2_1
XFILLER_97_193 VPWR VGND VPWR VGND sky130_ef_sc_hd__decap_12
XFILLER_73_517 VPWR VGND VPWR VGND sky130_ef_sc_hd__decap_12
X_3279_ net624 net281 _2053_ VGND VGND VPWR VPWR _0842_ sky130_fd_sc_hd__mux2_1
XPHY_EDGE_ROW_55_Right_55 VGND VGND VPWR VPWR sky130_fd_sc_hd__decap_3
X_5018_ clknet_leaf_63_clk _1073_ VGND VGND VPWR VPWR lsu.store_fifo.queue\[13\]\[7\]
+ sky130_fd_sc_hd__dfxtp_1
XFILLER_42_78 VGND VGND VPWR VPWR sky130_fd_sc_hd__decap_6
XPHY_EDGE_ROW_64_Right_64 VGND VGND VPWR VPWR sky130_fd_sc_hd__decap_3
XFILLER_3_39 VPWR VGND VPWR VGND sky130_ef_sc_hd__decap_12
XFILLER_49_503 VGND VGND VPWR VPWR sky130_fd_sc_hd__fill_1
XFILLER_88_193 VGND VGND VPWR VPWR sky130_fd_sc_hd__decap_3
XFILLER_76_333 VPWR VGND VPWR VGND sky130_ef_sc_hd__decap_12
XPHY_EDGE_ROW_73_Right_73 VGND VGND VPWR VPWR sky130_fd_sc_hd__decap_3
XTAP_TAPCELL_ROW_19_439 VGND VPWR sky130_fd_sc_hd__tapvpwrvgnd_1
XTAP_TAPCELL_ROW_47_748 VGND VPWR sky130_fd_sc_hd__tapvpwrvgnd_1
XPHY_EDGE_ROW_82_Right_82 VGND VGND VPWR VPWR sky130_fd_sc_hd__decap_3
Xlsu_wrapper_464 VGND VGND VPWR VPWR lsu_wrapper_464/HI store_data[27] sky130_fd_sc_hd__conb_1
Xlsu_wrapper_453 VGND VGND VPWR VPWR lsu_wrapper_453/HI store_data[16] sky130_fd_sc_hd__conb_1
X_2650_ net291 net977 _2019_ VGND VGND VPWR VPWR _0177_ sky130_fd_sc_hd__mux2_1
X_2581_ net43 net262 VGND VGND VPWR VPWR _1973_ sky130_fd_sc_hd__and2_1
XTAP_TAPCELL_ROW_74_1046 VGND VPWR sky130_fd_sc_hd__tapvpwrvgnd_1
X_4320_ clknet_leaf_17_clk _0377_ VGND VGND VPWR VPWR lsu.load_fifo.queue\[10\]\[26\]
+ sky130_fd_sc_hd__dfxtp_1
X_4251_ clknet_leaf_70_clk _0308_ VGND VGND VPWR VPWR lsu.store_fifo.queue\[2\]\[9\]
+ sky130_fd_sc_hd__dfxtp_1
XPHY_EDGE_ROW_91_Right_91 VGND VGND VPWR VPWR sky130_fd_sc_hd__decap_3
X_3202_ net718 net294 net204 VGND VGND VPWR VPWR _0703_ sky130_fd_sc_hd__mux2_1
X_4182_ clknet_leaf_48_clk _0239_ VGND VGND VPWR VPWR lsu.store_fifo.queue\[8\]\[0\]
+ sky130_fd_sc_hd__dfxtp_1
XFILLER_94_152 VPWR VGND VPWR VGND sky130_ef_sc_hd__decap_12
X_3133_ net596 net300 net182 VGND VGND VPWR VPWR _0636_ sky130_fd_sc_hd__mux2_1
X_3064_ net918 net306 net209 VGND VGND VPWR VPWR _0569_ sky130_fd_sc_hd__mux2_1
XTAP_TAPCELL_ROW_85_1164 VGND VPWR sky130_fd_sc_hd__tapvpwrvgnd_1
XFILLER_23_447 VGND VGND VPWR VPWR sky130_fd_sc_hd__fill_1
XFILLER_35_285 VGND VGND VPWR VPWR sky130_fd_sc_hd__fill_1
XFILLER_11_609 VGND VGND VPWR VPWR sky130_fd_sc_hd__decap_6
X_3966_ _1409_ _1411_ _1408_ _1410_ net356 net364 VGND VGND VPWR VPWR _1412_ sky130_fd_sc_hd__mux4_1
X_2917_ net526 net330 net220 VGND VGND VPWR VPWR _0429_ sky130_fd_sc_hd__mux2_1
X_3897_ net1254 _1352_ net255 VGND VGND VPWR VPWR _1017_ sky130_fd_sc_hd__mux2_1
X_2848_ net571 net339 net224 VGND VGND VPWR VPWR _0359_ sky130_fd_sc_hd__mux2_1
X_2779_ net278 net1012 _2030_ VGND VGND VPWR VPWR _0295_ sky130_fd_sc_hd__mux2_1
XTAP_TAPCELL_ROW_96_1282 VGND VPWR sky130_fd_sc_hd__tapvpwrvgnd_1
Xhold131 lsu.load_fifo.queue\[4\]\[24\] VGND VGND VPWR VPWR net599 sky130_fd_sc_hd__dlygate4sd3_1
Xhold120 lsu.load_fifo.queue\[7\]\[20\] VGND VGND VPWR VPWR net588 sky130_fd_sc_hd__dlygate4sd3_1
X_4518_ clknet_leaf_12_clk _0575_ VGND VGND VPWR VPWR lsu.load_fifo.queue\[2\]\[30\]
+ sky130_fd_sc_hd__dfxtp_1
Xhold153 lsu.load_fifo.queue\[12\]\[4\] VGND VGND VPWR VPWR net621 sky130_fd_sc_hd__dlygate4sd3_1
Xhold142 lsu.load_fifo.queue\[12\]\[12\] VGND VGND VPWR VPWR net610 sky130_fd_sc_hd__dlygate4sd3_1
Xhold164 lsu.load_fifo.queue\[10\]\[16\] VGND VGND VPWR VPWR net632 sky130_fd_sc_hd__dlygate4sd3_1
Xhold175 lsu.load_fifo.queue\[15\]\[11\] VGND VGND VPWR VPWR net643 sky130_fd_sc_hd__dlygate4sd3_1
Xhold186 lsu.load_fifo.queue\[4\]\[9\] VGND VGND VPWR VPWR net654 sky130_fd_sc_hd__dlygate4sd3_1
X_4449_ clknet_leaf_68_clk _0506_ VGND VGND VPWR VPWR lsu.load_fifo.queue\[4\]\[25\]
+ sky130_fd_sc_hd__dfxtp_1
Xhold197 lsu.load_fifo.queue\[2\]\[5\] VGND VGND VPWR VPWR net665 sky130_fd_sc_hd__dlygate4sd3_1
XFILLER_39_591 VGND VGND VPWR VPWR sky130_fd_sc_hd__decap_3
XTAP_TAPCELL_ROW_16_409 VGND VPWR sky130_fd_sc_hd__tapvpwrvgnd_1
XTAP_TAPCELL_ROW_44_718 VGND VPWR sky130_fd_sc_hd__tapvpwrvgnd_1
XFILLER_54_561 VGND VGND VPWR VPWR sky130_fd_sc_hd__decap_6
XFILLER_81_391 VGND VGND VPWR VPWR sky130_fd_sc_hd__fill_1
XFILLER_41_222 VGND VGND VPWR VPWR sky130_fd_sc_hd__fill_2
XFILLER_14_469 VGND VGND VPWR VPWR sky130_fd_sc_hd__decap_6
XTAP_TAPCELL_ROW_24_497 VGND VPWR sky130_fd_sc_hd__tapvpwrvgnd_1
XFILLER_6_613 VPWR VGND VPWR VGND sky130_ef_sc_hd__decap_12
XFILLER_1_373 VPWR VGND VPWR VGND sky130_ef_sc_hd__decap_12
XFILLER_76_141 VGND VGND VPWR VPWR sky130_fd_sc_hd__decap_3
XFILLER_91_111 VGND VGND VPWR VPWR sky130_fd_sc_hd__fill_1
XFILLER_91_166 VGND VGND VPWR VPWR sky130_fd_sc_hd__fill_2
XFILLER_60_531 VGND VGND VPWR VPWR sky130_fd_sc_hd__fill_1
X_3820_ _1284_ _1286_ _1283_ _1285_ net358 net364 VGND VGND VPWR VPWR _1287_ sky130_fd_sc_hd__mux4_1
X_3751_ _1161_ _1232_ net272 _1125_ VGND VGND VPWR VPWR _1085_ sky130_fd_sc_hd__o2bb2a_1
X_2702_ net770 net297 net232 VGND VGND VPWR VPWR _0226_ sky130_fd_sc_hd__mux2_1
XFILLER_71_3 VGND VGND VPWR VPWR sky130_fd_sc_hd__fill_1
XFILLER_9_473 VPWR VGND VPWR VGND sky130_ef_sc_hd__decap_12
X_3682_ _1158_ _1159_ VGND VGND VPWR VPWR _1164_ sky130_fd_sc_hd__xnor2_1
X_2633_ net420 _1442_ VGND VGND VPWR VPWR _2009_ sky130_fd_sc_hd__nor2_1
X_2564_ lsu.current_load_addr\[12\] _1960_ net161 VGND VGND VPWR VPWR _0739_ sky130_fd_sc_hd__mux2_4
X_4303_ clknet_leaf_83_clk _0360_ VGND VGND VPWR VPWR lsu.load_fifo.queue\[10\]\[9\]
+ sky130_fd_sc_hd__dfxtp_1
X_2495_ _1908_ _1909_ lsu.current_store_addr\[0\] net241 VGND VGND VPWR VPWR _0789_
+ sky130_fd_sc_hd__o2bb2a_1
X_4234_ clknet_leaf_57_clk _0291_ VGND VGND VPWR VPWR lsu.store_fifo.queue\[3\]\[2\]
+ sky130_fd_sc_hd__dfxtp_1
X_4165_ clknet_leaf_68_clk _0222_ VGND VGND VPWR VPWR lsu.load_fifo.queue\[11\]\[25\]
+ sky130_fd_sc_hd__dfxtp_1
XFILLER_95_461 VGND VGND VPWR VPWR sky130_fd_sc_hd__decap_4
X_3116_ net615 net335 net183 VGND VGND VPWR VPWR _0619_ sky130_fd_sc_hd__mux2_1
X_4096_ lsu.store_fifo.queue\[0\]\[1\] lsu.store_fifo.queue\[1\]\[1\] lsu.store_fifo.queue\[2\]\[1\]
+ lsu.store_fifo.queue\[3\]\[1\] net411 net406 VGND VGND VPWR VPWR _1528_ sky130_fd_sc_hd__mux4_1
X_3047_ net891 net340 net209 VGND VGND VPWR VPWR _0552_ sky130_fd_sc_hd__mux2_1
XFILLER_63_380 VGND VGND VPWR VPWR sky130_fd_sc_hd__decap_6
XFILLER_63_391 VGND VGND VPWR VPWR sky130_fd_sc_hd__fill_1
XFILLER_11_417 VPWR VGND VPWR VGND sky130_ef_sc_hd__decap_12
X_4998_ clknet_leaf_8_clk _1053_ VGND VGND VPWR VPWR lsu.load_fifo.queue\[14\]\[19\]
+ sky130_fd_sc_hd__dfxtp_1
XTAP_TAPCELL_ROW_98_1311 VGND VPWR sky130_fd_sc_hd__tapvpwrvgnd_1
X_3949_ lsu.load_fifo.queue\[4\]\[7\] lsu.load_fifo.queue\[5\]\[7\] lsu.load_fifo.queue\[6\]\[7\]
+ lsu.load_fifo.queue\[7\]\[7\] net396 net379 VGND VGND VPWR VPWR _1397_ sky130_fd_sc_hd__mux4_1
XFILLER_99_18 VPWR VGND VPWR VGND sky130_ef_sc_hd__decap_12
XTAP_TAPCELL_ROW_21_456 VGND VPWR sky130_fd_sc_hd__tapvpwrvgnd_1
XFILLER_105_533 VGND VGND VPWR VPWR sky130_fd_sc_hd__fill_1
XFILLER_105_588 VPWR VGND VPWR VGND sky130_ef_sc_hd__decap_12
Xfanout441 net442 VGND VGND VPWR VPWR net441 sky130_fd_sc_hd__buf_4
Xfanout430 net434 VGND VGND VPWR VPWR net430 sky130_fd_sc_hd__buf_4
XFILLER_19_517 VPWR VGND VPWR VGND sky130_ef_sc_hd__decap_12
XFILLER_0_29 VPWR VGND VPWR VGND sky130_ef_sc_hd__decap_12
XTAP_TAPCELL_ROW_29_545 VGND VPWR sky130_fd_sc_hd__tapvpwrvgnd_1
XTAP_TAPCELL_ROW_57_854 VGND VPWR sky130_fd_sc_hd__tapvpwrvgnd_1
XTAP_TAPCELL_ROW_103_1359 VGND VPWR sky130_fd_sc_hd__tapvpwrvgnd_1
XFILLER_42_586 VGND VGND VPWR VPWR sky130_fd_sc_hd__fill_2
XFILLER_6_421 VPWR VGND VPWR VGND sky130_ef_sc_hd__decap_12
XFILLER_89_51 VGND VGND VPWR VPWR sky130_fd_sc_hd__decap_4
XTAP_TAPCELL_ROW_71_1016 VGND VPWR sky130_fd_sc_hd__tapvpwrvgnd_1
X_2280_ lsu.store_counter\[18\] net242 _1733_ lsu.store_counter\[19\] VGND VGND VPWR
+ VPWR _1742_ sky130_fd_sc_hd__a31o_1
XFILLER_36_6 VGND VGND VPWR VPWR sky130_fd_sc_hd__decap_3
XFILLER_18_550 VPWR VGND VPWR VGND sky130_ef_sc_hd__decap_12
X_4921_ clknet_leaf_31_clk _0976_ VGND VGND VPWR VPWR lsu.load_fifo.queue\[13\]\[16\]
+ sky130_fd_sc_hd__dfxtp_1
X_4852_ clknet_leaf_39_clk _0907_ _0102_ VGND VGND VPWR VPWR lsu.load_counter\[2\]
+ sky130_fd_sc_hd__dfrtp_1
XTAP_TAPCELL_ROW_82_1134 VGND VPWR sky130_fd_sc_hd__tapvpwrvgnd_1
XFILLER_20_203 VGND VGND VPWR VPWR sky130_fd_sc_hd__fill_1
X_3803_ lsu.load_fifo.queue\[0\]\[28\] lsu.load_fifo.queue\[1\]\[28\] lsu.load_fifo.queue\[2\]\[28\]
+ lsu.load_fifo.queue\[3\]\[28\] net394 net377 VGND VGND VPWR VPWR _1272_ sky130_fd_sc_hd__mux4_1
X_4783_ clknet_leaf_67_clk _0840_ VGND VGND VPWR VPWR lsu.store_fifo.queue\[0\]\[3\]
+ sky130_fd_sc_hd__dfxtp_1
X_3734_ _1214_ _1215_ VGND VGND VPWR VPWR _1216_ sky130_fd_sc_hd__nand2_1
XFILLER_9_281 VGND VGND VPWR VPWR sky130_fd_sc_hd__decap_6
X_3665_ _1140_ _1146_ VGND VGND VPWR VPWR _1147_ sky130_fd_sc_hd__nand2b_1
Xclkload40 clknet_leaf_26_clk VGND VGND VPWR VPWR clkload40/Y sky130_fd_sc_hd__clkinv_8
X_2616_ _1777_ lsu.load_fifo.w_en VGND VGND VPWR VPWR _1996_ sky130_fd_sc_hd__and2b_1
Xclkload62 clknet_leaf_62_clk VGND VGND VPWR VPWR clkload62/Y sky130_fd_sc_hd__inv_6
Xclkload51 clknet_leaf_56_clk VGND VGND VPWR VPWR clkload51/Y sky130_fd_sc_hd__inv_8
XTAP_TAPCELL_ROW_93_1252 VGND VPWR sky130_fd_sc_hd__tapvpwrvgnd_1
Xclkload73 clknet_leaf_40_clk VGND VGND VPWR VPWR clkload73/Y sky130_fd_sc_hd__inv_6
X_3596_ net424 VGND VGND VPWR VPWR _0160_ sky130_fd_sc_hd__inv_2
Xclkload84 clknet_leaf_50_clk VGND VGND VPWR VPWR clkload84/Y sky130_fd_sc_hd__inv_6
X_2547_ net31 net260 _1946_ _1947_ VGND VGND VPWR VPWR _1948_ sky130_fd_sc_hd__a22o_1
XFILLER_87_225 VPWR VGND VPWR VGND sky130_ef_sc_hd__decap_12
X_2478_ net269 _1844_ net252 VGND VGND VPWR VPWR _1898_ sky130_fd_sc_hd__a21o_1
XFILLER_87_269 VGND VGND VPWR VPWR sky130_fd_sc_hd__decap_8
X_4217_ clknet_leaf_71_clk _0274_ VGND VGND VPWR VPWR lsu.store_fifo.queue\[5\]\[5\]
+ sky130_fd_sc_hd__dfxtp_1
X_4148_ clknet_leaf_54_clk _0205_ VGND VGND VPWR VPWR lsu.load_fifo.queue\[11\]\[8\]
+ sky130_fd_sc_hd__dfxtp_1
X_4079_ lsu.store_fifo.queue\[12\]\[3\] lsu.store_fifo.queue\[13\]\[3\] lsu.store_fifo.queue\[14\]\[3\]
+ lsu.store_fifo.queue\[15\]\[3\] net413 net407 VGND VGND VPWR VPWR _1513_ sky130_fd_sc_hd__mux4_1
XFILLER_83_486 VPWR VGND VPWR VGND sky130_ef_sc_hd__decap_12
XTAP_TAPCELL_ROW_26_515 VGND VPWR sky130_fd_sc_hd__tapvpwrvgnd_1
XTAP_TAPCELL_ROW_54_824 VGND VPWR sky130_fd_sc_hd__tapvpwrvgnd_1
XFILLER_24_542 VGND VGND VPWR VPWR sky130_fd_sc_hd__fill_1
XFILLER_11_247 VGND VGND VPWR VPWR sky130_fd_sc_hd__decap_4
XFILLER_11_225 VPWR VGND VPWR VGND sky130_ef_sc_hd__decap_12
Xclkload1 clknet_3_2__leaf_clk VGND VGND VPWR VPWR clkload1/X sky130_fd_sc_hd__clkbuf_8
XFILLER_1_3 VPWR VGND VPWR VGND sky130_ef_sc_hd__decap_12
XFILLER_59_21 VGND VGND VPWR VPWR sky130_fd_sc_hd__fill_2
XFILLER_78_269 VGND VGND VPWR VPWR sky130_fd_sc_hd__decap_4
Xfanout260 net261 VGND VGND VPWR VPWR net260 sky130_fd_sc_hd__buf_2
XFILLER_93_217 VGND VGND VPWR VPWR sky130_fd_sc_hd__decap_6
XTAP_TAPCELL_ROW_6_295 VGND VPWR sky130_fd_sc_hd__tapvpwrvgnd_1
XFILLER_19_314 VPWR VGND VPWR VGND sky130_ef_sc_hd__decap_12
Xfanout282 acc.data_out\[4\] VGND VGND VPWR VPWR net282 sky130_fd_sc_hd__clkbuf_2
Xfanout271 _1114_ VGND VGND VPWR VPWR net271 sky130_fd_sc_hd__buf_2
XFILLER_75_53 VGND VGND VPWR VPWR sky130_fd_sc_hd__decap_3
Xfanout293 lsu.load_fifo.data_in\[31\] VGND VGND VPWR VPWR net293 sky130_fd_sc_hd__buf_1
XFILLER_46_133 VGND VGND VPWR VPWR sky130_fd_sc_hd__fill_1
XFILLER_74_475 VGND VGND VPWR VPWR sky130_fd_sc_hd__fill_1
XFILLER_15_553 VGND VGND VPWR VPWR sky130_fd_sc_hd__decap_6
XFILLER_15_597 VPWR VGND VPWR VGND sky130_ef_sc_hd__decap_12
XFILLER_42_394 VGND VGND VPWR VPWR sky130_fd_sc_hd__fill_1
Xhold708 lsu.store_fifo.queue\[13\]\[6\] VGND VGND VPWR VPWR net1176 sky130_fd_sc_hd__dlygate4sd3_1
Xhold719 net143 VGND VGND VPWR VPWR net1187 sky130_fd_sc_hd__dlygate4sd3_1
X_3450_ net432 VGND VGND VPWR VPWR _0014_ sky130_fd_sc_hd__inv_2
X_2401_ lsu.storer_state\[0\] _1837_ VGND VGND VPWR VPWR _1838_ sky130_fd_sc_hd__nand2_1
X_3381_ net294 net1006 net171 VGND VGND VPWR VPWR _0990_ sky130_fd_sc_hd__mux2_1
X_2332_ _1255_ _1771_ _1770_ VGND VGND VPWR VPWR _1772_ sky130_fd_sc_hd__o21ai_1
XFILLER_69_225 VGND VGND VPWR VPWR sky130_fd_sc_hd__decap_4
X_2263_ lsu.store_counter\[7\] lsu.store_counter\[6\] _1727_ VGND VGND VPWR VPWR _1728_
+ sky130_fd_sc_hd__and3_1
X_4002_ _1440_ _1441_ VGND VGND VPWR VPWR _1442_ sky130_fd_sc_hd__nor2_1
X_2194_ _1097_ _1676_ VGND VGND VPWR VPWR _1682_ sky130_fd_sc_hd__and2_1
XFILLER_53_604 VGND VGND VPWR VPWR sky130_fd_sc_hd__fill_1
X_4904_ clknet_leaf_74_clk _0959_ VGND VGND VPWR VPWR lsu.load_fifo.queue\[12\]\[31\]
+ sky130_fd_sc_hd__dfxtp_1
X_4835_ clknet_leaf_45_clk _0892_ _0085_ VGND VGND VPWR VPWR lsu.store_counter\[12\]
+ sky130_fd_sc_hd__dfrtp_1
X_4766_ clknet_leaf_44_clk net1123 VGND VGND VPWR VPWR net130 sky130_fd_sc_hd__dfxtp_1
XTAP_TAPCELL_ROW_31_573 VGND VPWR sky130_fd_sc_hd__tapvpwrvgnd_1
X_3717_ acc.byte3\[2\] acc.byte2\[2\] VGND VGND VPWR VPWR _1199_ sky130_fd_sc_hd__or2_1
X_4697_ clknet_leaf_64_clk _0754_ VGND VGND VPWR VPWR lsu.store_fifo.queue\[14\]\[1\]
+ sky130_fd_sc_hd__dfxtp_1
XFILLER_20_26 VGND VGND VPWR VPWR sky130_fd_sc_hd__fill_2
X_3648_ acc.byte1\[6\] acc.byte0\[6\] VGND VGND VPWR VPWR _1130_ sky130_fd_sc_hd__nand2_1
X_3579_ net427 VGND VGND VPWR VPWR _0143_ sky130_fd_sc_hd__inv_2
XFILLER_0_405 VPWR VGND VPWR VGND sky130_ef_sc_hd__decap_12
XFILLER_88_545 VGND VGND VPWR VPWR sky130_fd_sc_hd__decap_8
XFILLER_0_449 VPWR VGND VPWR VGND sky130_ef_sc_hd__decap_12
XFILLER_29_24 VGND VGND VPWR VPWR sky130_fd_sc_hd__fill_1
XFILLER_88_578 VGND VGND VPWR VPWR sky130_fd_sc_hd__fill_1
Xhold46 lsu.load_fifo.queue\[7\]\[10\] VGND VGND VPWR VPWR net514 sky130_fd_sc_hd__dlygate4sd3_1
Xhold35 lsu.load_fifo.queue\[10\]\[0\] VGND VGND VPWR VPWR net503 sky130_fd_sc_hd__dlygate4sd3_1
XFILLER_29_57 VGND VGND VPWR VPWR sky130_fd_sc_hd__decap_4
XFILLER_102_399 VGND VGND VPWR VPWR sky130_fd_sc_hd__fill_2
Xhold68 lsu.load_fifo.queue\[8\]\[12\] VGND VGND VPWR VPWR net536 sky130_fd_sc_hd__dlygate4sd3_1
Xhold57 lsu.load_fifo.queue\[3\]\[2\] VGND VGND VPWR VPWR net525 sky130_fd_sc_hd__dlygate4sd3_1
Xhold79 lsu.store_fifo.queue\[10\]\[1\] VGND VGND VPWR VPWR net547 sky130_fd_sc_hd__dlygate4sd3_1
XTAP_TAPCELL_ROW_67_971 VGND VPWR sky130_fd_sc_hd__tapvpwrvgnd_1
XTAP_TAPCELL_ROW_3_265 VGND VPWR sky130_fd_sc_hd__tapvpwrvgnd_1
XTAP_TAPCELL_ROW_39_662 VGND VPWR sky130_fd_sc_hd__tapvpwrvgnd_1
XFILLER_71_434 VPWR VGND VPWR VGND sky130_ef_sc_hd__decap_12
XFILLER_43_158 VGND VGND VPWR VPWR sky130_fd_sc_hd__decap_4
XFILLER_12_501 VPWR VGND VPWR VGND sky130_ef_sc_hd__decap_12
XTAP_TAPCELL_ROW_100_1329 VGND VPWR sky130_fd_sc_hd__tapvpwrvgnd_1
XFILLER_12_545 VPWR VGND VPWR VGND sky130_ef_sc_hd__decap_12
XFILLER_12_589 VPWR VGND VPWR VGND sky130_ef_sc_hd__decap_12
XFILLER_98_309 VPWR VGND VPWR VGND sky130_ef_sc_hd__decap_12
XFILLER_86_41 VPWR VGND VPWR VGND sky130_ef_sc_hd__decap_12
XFILLER_66_239 VGND VGND VPWR VPWR sky130_fd_sc_hd__decap_6
XFILLER_19_90 VGND VGND VPWR VPWR sky130_fd_sc_hd__decap_4
X_2950_ net330 net602 net216 VGND VGND VPWR VPWR _0461_ sky130_fd_sc_hd__mux2_1
X_2881_ net893 net336 net193 VGND VGND VPWR VPWR _0392_ sky130_fd_sc_hd__mux2_1
X_4620_ clknet_leaf_19_clk _0677_ VGND VGND VPWR VPWR lsu.load_fifo.queue\[15\]\[4\]
+ sky130_fd_sc_hd__dfxtp_1
X_4551_ clknet_leaf_76_clk _0608_ VGND VGND VPWR VPWR lsu.load_fifo.queue\[1\]\[31\]
+ sky130_fd_sc_hd__dfxtp_1
X_3502_ net444 VGND VGND VPWR VPWR _0066_ sky130_fd_sc_hd__inv_2
Xmax_cap235 net236 VGND VGND VPWR VPWR net235 sky130_fd_sc_hd__clkbuf_1
Xhold527 lsu.load_fifo.queue\[8\]\[7\] VGND VGND VPWR VPWR net995 sky130_fd_sc_hd__dlygate4sd3_1
Xhold505 lsu.load_fifo.queue\[10\]\[22\] VGND VGND VPWR VPWR net973 sky130_fd_sc_hd__dlygate4sd3_1
X_4482_ clknet_leaf_7_clk _0539_ VGND VGND VPWR VPWR lsu.load_fifo.queue\[3\]\[26\]
+ sky130_fd_sc_hd__dfxtp_1
Xhold516 lsu.load_fifo.queue\[6\]\[8\] VGND VGND VPWR VPWR net984 sky130_fd_sc_hd__dlygate4sd3_1
XTAP_TAPCELL_ROW_77_1077 VGND VPWR sky130_fd_sc_hd__tapvpwrvgnd_1
Xhold549 lsu.load_fifo.queue\[9\]\[9\] VGND VGND VPWR VPWR net1017 sky130_fd_sc_hd__dlygate4sd3_1
X_3433_ net606 net280 _2059_ VGND VGND VPWR VPWR _1091_ sky130_fd_sc_hd__mux2_1
Xhold538 lsu.load_fifo.queue\[13\]\[30\] VGND VGND VPWR VPWR net1006 sky130_fd_sc_hd__dlygate4sd3_1
XFILLER_106_18 VGND VGND VPWR VPWR sky130_fd_sc_hd__decap_6
XTAP_TAPCELL_ROW_90_1222 VGND VPWR sky130_fd_sc_hd__tapvpwrvgnd_1
XFILLER_106_29 VPWR VGND VPWR VGND sky130_ef_sc_hd__decap_12
X_3364_ net328 net1179 net169 VGND VGND VPWR VPWR _0973_ sky130_fd_sc_hd__mux2_1
X_3295_ net334 net48 net250 VGND VGND VPWR VPWR _0857_ sky130_fd_sc_hd__mux2_1
X_2315_ lsu.store_counter\[4\] net239 _1726_ lsu.store_counter\[5\] VGND VGND VPWR
+ VPWR _1763_ sky130_fd_sc_hd__a31o_1
X_2246_ net1278 _1712_ lsu.acc_state\[1\] VGND VGND VPWR VPWR _0904_ sky130_fd_sc_hd__mux2_1
X_5034_ clknet_leaf_60_clk _1089_ VGND VGND VPWR VPWR lsu.store_fifo.queue\[12\]\[3\]
+ sky130_fd_sc_hd__dfxtp_1
X_2177_ lsu.load_counter\[2\] lsu.load_counter\[1\] lsu.load_counter\[0\] VGND VGND
+ VPWR VPWR _1667_ sky130_fd_sc_hd__and3_1
XTAP_TAPCELL_ROW_0_224 VGND VPWR sky130_fd_sc_hd__tapvpwrvgnd_1
XTAP_TAPCELL_ROW_0_235 VGND VPWR sky130_fd_sc_hd__tapvpwrvgnd_1
XTAP_TAPCELL_ROW_88_1195 VGND VPWR sky130_fd_sc_hd__tapvpwrvgnd_1
XTAP_TAPCELL_ROW_36_621 VGND VPWR sky130_fd_sc_hd__tapvpwrvgnd_1
XTAP_TAPCELL_ROW_64_930 VGND VPWR sky130_fd_sc_hd__tapvpwrvgnd_1
XFILLER_25_169 VGND VGND VPWR VPWR sky130_fd_sc_hd__decap_4
XFILLER_40_139 VGND VGND VPWR VPWR sky130_fd_sc_hd__fill_1
X_4818_ clknet_leaf_20_clk _0875_ VGND VGND VPWR VPWR lsu.load_fifo.data_in\[28\]
+ sky130_fd_sc_hd__dfxtp_1
X_4749_ clknet_leaf_46_clk _0806_ _0063_ VGND VGND VPWR VPWR lsu.current_store_addr\[17\]
+ sky130_fd_sc_hd__dfrtp_1
XTAP_TAPCELL_ROW_8_313 VGND VPWR sky130_fd_sc_hd__tapvpwrvgnd_1
XFILLER_102_141 VGND VGND VPWR VPWR sky130_fd_sc_hd__fill_1
XFILLER_102_130 VGND VGND VPWR VPWR sky130_fd_sc_hd__decap_3
XFILLER_0_279 VGND VGND VPWR VPWR sky130_fd_sc_hd__fill_1
XFILLER_17_615 VGND VGND VPWR VPWR sky130_fd_sc_hd__fill_1
XFILLER_29_486 VGND VGND VPWR VPWR sky130_fd_sc_hd__fill_2
XFILLER_71_275 VGND VGND VPWR VPWR sky130_fd_sc_hd__decap_4
XFILLER_71_264 VGND VGND VPWR VPWR sky130_fd_sc_hd__decap_3
XFILLER_32_607 VGND VGND VPWR VPWR sky130_fd_sc_hd__fill_1
XFILLER_24_180 VGND VGND VPWR VPWR sky130_fd_sc_hd__decap_6
XTAP_TAPCELL_ROW_70_999 VGND VPWR sky130_fd_sc_hd__tapvpwrvgnd_1
XFILLER_8_346 VGND VGND VPWR VPWR sky130_fd_sc_hd__decap_3
XFILLER_99_607 VGND VGND VPWR VPWR sky130_fd_sc_hd__fill_1
XFILLER_97_51 VGND VGND VPWR VPWR sky130_fd_sc_hd__decap_4
XFILLER_94_301 VGND VGND VPWR VPWR sky130_fd_sc_hd__decap_6
X_2100_ _1586_ lsu.load_counter\[15\] _1588_ _1589_ VGND VGND VPWR VPWR _1590_ sky130_fd_sc_hd__a211o_1
X_3080_ net341 net1082 net188 VGND VGND VPWR VPWR _0584_ sky130_fd_sc_hd__mux2_1
XFILLER_67_559 VGND VGND VPWR VPWR sky130_fd_sc_hd__fill_1
XFILLER_94_345 VGND VGND VPWR VPWR sky130_fd_sc_hd__decap_8
XFILLER_54_209 VGND VGND VPWR VPWR sky130_fd_sc_hd__fill_1
X_3982_ lsu.load_fifo.queue\[4\]\[2\] lsu.load_fifo.queue\[5\]\[2\] lsu.load_fifo.queue\[6\]\[2\]
+ lsu.load_fifo.queue\[7\]\[2\] net393 net376 VGND VGND VPWR VPWR _1425_ sky130_fd_sc_hd__mux4_1
XFILLER_23_629 VGND VGND VPWR VPWR sky130_fd_sc_hd__fill_1
XTAP_TAPCELL_ROW_61_900 VGND VPWR sky130_fd_sc_hd__tapvpwrvgnd_1
XFILLER_62_275 VGND VGND VPWR VPWR sky130_fd_sc_hd__fill_1
X_2933_ net932 net298 net220 VGND VGND VPWR VPWR _0445_ sky130_fd_sc_hd__mux2_1
X_2864_ net830 net307 net225 VGND VGND VPWR VPWR _0375_ sky130_fd_sc_hd__mux2_1
XTAP_TAPCELL_ROW_13_370 VGND VPWR sky130_fd_sc_hd__tapvpwrvgnd_1
X_4603_ clknet_leaf_9_clk _0660_ VGND VGND VPWR VPWR lsu.load_fifo.queue\[8\]\[19\]
+ sky130_fd_sc_hd__dfxtp_1
X_2795_ net290 net754 _2032_ VGND VGND VPWR VPWR _0309_ sky130_fd_sc_hd__mux2_1
Xhold302 lsu.load_fifo.queue\[11\]\[29\] VGND VGND VPWR VPWR net770 sky130_fd_sc_hd__dlygate4sd3_1
X_4534_ clknet_leaf_1_clk _0591_ VGND VGND VPWR VPWR lsu.load_fifo.queue\[1\]\[14\]
+ sky130_fd_sc_hd__dfxtp_1
Xhold324 lsu.load_fifo.queue\[0\]\[7\] VGND VGND VPWR VPWR net792 sky130_fd_sc_hd__dlygate4sd3_1
Xhold313 lsu.load_fifo.queue\[11\]\[18\] VGND VGND VPWR VPWR net781 sky130_fd_sc_hd__dlygate4sd3_1
Xhold335 lsu.store_fifo.queue\[0\]\[8\] VGND VGND VPWR VPWR net803 sky130_fd_sc_hd__dlygate4sd3_1
Xhold368 lsu.load_fifo.queue\[2\]\[21\] VGND VGND VPWR VPWR net836 sky130_fd_sc_hd__dlygate4sd3_1
Xhold357 net134 VGND VGND VPWR VPWR net825 sky130_fd_sc_hd__dlygate4sd3_1
X_4465_ clknet_leaf_83_clk _0522_ VGND VGND VPWR VPWR lsu.load_fifo.queue\[3\]\[9\]
+ sky130_fd_sc_hd__dfxtp_1
Xhold346 lsu.load_fifo.queue\[15\]\[8\] VGND VGND VPWR VPWR net814 sky130_fd_sc_hd__dlygate4sd3_1
Xhold379 lsu.load_fifo.queue\[13\]\[27\] VGND VGND VPWR VPWR net847 sky130_fd_sc_hd__dlygate4sd3_1
X_4396_ clknet_leaf_19_clk _0453_ VGND VGND VPWR VPWR lsu.load_fifo.queue\[5\]\[4\]
+ sky130_fd_sc_hd__dfxtp_1
X_3416_ net420 _2012_ _2048_ VGND VGND VPWR VPWR _2058_ sky130_fd_sc_hd__or3_4
XFILLER_100_601 VGND VGND VPWR VPWR sky130_fd_sc_hd__decap_8
XFILLER_97_161 VGND VGND VPWR VPWR sky130_fd_sc_hd__decap_6
X_3347_ net673 net296 net175 VGND VGND VPWR VPWR _0957_ sky130_fd_sc_hd__mux2_1
XFILLER_85_345 VPWR VGND VPWR VGND sky130_ef_sc_hd__decap_12
X_3278_ net1177 net282 _2053_ VGND VGND VPWR VPWR _0841_ sky130_fd_sc_hd__mux2_1
X_5017_ clknet_leaf_50_clk _1072_ VGND VGND VPWR VPWR lsu.store_fifo.queue\[13\]\[6\]
+ sky130_fd_sc_hd__dfxtp_1
X_2229_ _1104_ _1669_ VGND VGND VPWR VPWR _1703_ sky130_fd_sc_hd__and2_1
XFILLER_73_529 VGND VGND VPWR VPWR sky130_fd_sc_hd__decap_3
XFILLER_38_261 VGND VGND VPWR VPWR sky130_fd_sc_hd__decap_8
XFILLER_26_456 VGND VGND VPWR VPWR sky130_fd_sc_hd__fill_1
XFILLER_38_294 VPWR VGND VPWR VGND sky130_ef_sc_hd__decap_12
XFILLER_14_629 VGND VGND VPWR VPWR sky130_fd_sc_hd__fill_1
XFILLER_21_183 VGND VGND VPWR VPWR sky130_fd_sc_hd__decap_4
XFILLER_103_483 VGND VGND VPWR VPWR sky130_fd_sc_hd__decap_8
XFILLER_49_548 VGND VGND VPWR VPWR sky130_fd_sc_hd__decap_3
XFILLER_67_54 VGND VGND VPWR VPWR sky130_fd_sc_hd__fill_2
XFILLER_67_65 VGND VGND VPWR VPWR sky130_fd_sc_hd__fill_2
XFILLER_67_76 VGND VGND VPWR VPWR sky130_fd_sc_hd__fill_2
XFILLER_91_337 VPWR VGND VPWR VGND sky130_ef_sc_hd__decap_12
XTAP_TAPCELL_ROW_47_749 VGND VPWR sky130_fd_sc_hd__tapvpwrvgnd_1
XFILLER_72_562 VGND VGND VPWR VPWR sky130_fd_sc_hd__fill_2
XPHY_EDGE_ROW_17_Left_124 VGND VGND VPWR VPWR sky130_fd_sc_hd__decap_3
XFILLER_32_448 VGND VGND VPWR VPWR sky130_fd_sc_hd__fill_2
XFILLER_40_481 VGND VGND VPWR VPWR sky130_fd_sc_hd__fill_1
Xlsu_wrapper_465 VGND VGND VPWR VPWR lsu_wrapper_465/HI store_data[28] sky130_fd_sc_hd__conb_1
Xlsu_wrapper_454 VGND VGND VPWR VPWR lsu_wrapper_454/HI store_data[17] sky130_fd_sc_hd__conb_1
XTAP_TAPCELL_ROW_10_340 VGND VPWR sky130_fd_sc_hd__tapvpwrvgnd_1
XFILLER_66_6 VGND VGND VPWR VPWR sky130_fd_sc_hd__decap_3
X_2580_ lsu.current_load_addr\[7\] _1923_ VGND VGND VPWR VPWR _1972_ sky130_fd_sc_hd__or2_1
XTAP_TAPCELL_ROW_74_1047 VGND VPWR sky130_fd_sc_hd__tapvpwrvgnd_1
XPHY_EDGE_ROW_26_Left_133 VGND VGND VPWR VPWR sky130_fd_sc_hd__decap_3
X_4250_ clknet_leaf_56_clk _0307_ VGND VGND VPWR VPWR lsu.store_fifo.queue\[2\]\[8\]
+ sky130_fd_sc_hd__dfxtp_1
X_3201_ net1227 net296 net204 VGND VGND VPWR VPWR _0702_ sky130_fd_sc_hd__mux2_1
X_4181_ clknet_leaf_65_clk _0238_ VGND VGND VPWR VPWR lsu.store_fifo.queue\[9\]\[9\]
+ sky130_fd_sc_hd__dfxtp_1
X_3132_ net857 net302 net183 VGND VGND VPWR VPWR _0635_ sky130_fd_sc_hd__mux2_1
XFILLER_94_164 VPWR VGND VPWR VGND sky130_ef_sc_hd__decap_12
X_3063_ net1106 net308 net207 VGND VGND VPWR VPWR _0568_ sky130_fd_sc_hd__mux2_1
XFILLER_94_197 VPWR VGND VPWR VGND sky130_ef_sc_hd__decap_12
XFILLER_82_359 VGND VGND VPWR VPWR sky130_fd_sc_hd__decap_4
XTAP_TAPCELL_ROW_85_1165 VGND VPWR sky130_fd_sc_hd__tapvpwrvgnd_1
XPHY_EDGE_ROW_35_Left_142 VGND VGND VPWR VPWR sky130_fd_sc_hd__decap_3
X_3965_ lsu.load_fifo.queue\[8\]\[5\] lsu.load_fifo.queue\[9\]\[5\] lsu.load_fifo.queue\[10\]\[5\]
+ lsu.load_fifo.queue\[11\]\[5\] net391 net374 VGND VGND VPWR VPWR _1411_ sky130_fd_sc_hd__mux4_1
X_2916_ net852 net332 net218 VGND VGND VPWR VPWR _0428_ sky130_fd_sc_hd__mux2_1
X_3896_ _1351_ _1348_ net359 VGND VGND VPWR VPWR _1352_ sky130_fd_sc_hd__mux2_1
X_2847_ net732 net340 net225 VGND VGND VPWR VPWR _0358_ sky130_fd_sc_hd__mux2_1
XFILLER_12_49 VGND VGND VPWR VPWR sky130_fd_sc_hd__decap_3
X_2778_ net280 net1213 _2030_ VGND VGND VPWR VPWR _0294_ sky130_fd_sc_hd__mux2_1
Xhold110 lsu.load_fifo.queue\[11\]\[30\] VGND VGND VPWR VPWR net578 sky130_fd_sc_hd__dlygate4sd3_1
XTAP_TAPCELL_ROW_96_1283 VGND VPWR sky130_fd_sc_hd__tapvpwrvgnd_1
X_4517_ clknet_leaf_23_clk _0574_ VGND VGND VPWR VPWR lsu.load_fifo.queue\[2\]\[29\]
+ sky130_fd_sc_hd__dfxtp_1
Xhold132 lsu.load_fifo.queue\[0\]\[1\] VGND VGND VPWR VPWR net600 sky130_fd_sc_hd__dlygate4sd3_1
Xhold143 lsu.load_fifo.queue\[12\]\[31\] VGND VGND VPWR VPWR net611 sky130_fd_sc_hd__dlygate4sd3_1
XPHY_EDGE_ROW_44_Left_151 VGND VGND VPWR VPWR sky130_fd_sc_hd__decap_3
Xhold121 lsu.load_fifo.queue\[4\]\[7\] VGND VGND VPWR VPWR net589 sky130_fd_sc_hd__dlygate4sd3_1
X_4448_ clknet_leaf_32_clk _0505_ VGND VGND VPWR VPWR lsu.load_fifo.queue\[4\]\[24\]
+ sky130_fd_sc_hd__dfxtp_1
Xhold154 lsu.load_fifo.queue\[8\]\[9\] VGND VGND VPWR VPWR net622 sky130_fd_sc_hd__dlygate4sd3_1
Xhold176 lsu.store_fifo.queue\[0\]\[1\] VGND VGND VPWR VPWR net644 sky130_fd_sc_hd__dlygate4sd3_1
Xhold165 lsu.load_fifo.queue\[15\]\[28\] VGND VGND VPWR VPWR net633 sky130_fd_sc_hd__dlygate4sd3_1
Xhold198 net116 VGND VGND VPWR VPWR net666 sky130_fd_sc_hd__dlygate4sd3_1
Xhold187 lsu.store_fifo.queue\[2\]\[2\] VGND VGND VPWR VPWR net655 sky130_fd_sc_hd__dlygate4sd3_1
XFILLER_98_492 VGND VGND VPWR VPWR sky130_fd_sc_hd__fill_2
X_4379_ clknet_leaf_9_clk _0436_ VGND VGND VPWR VPWR lsu.load_fifo.queue\[6\]\[19\]
+ sky130_fd_sc_hd__dfxtp_1
XFILLER_58_312 VGND VGND VPWR VPWR sky130_fd_sc_hd__fill_2
XFILLER_100_475 VGND VGND VPWR VPWR sky130_fd_sc_hd__fill_1
XFILLER_100_464 VGND VGND VPWR VPWR sky130_fd_sc_hd__fill_1
XFILLER_37_57 VGND VGND VPWR VPWR sky130_fd_sc_hd__decap_6
XFILLER_58_378 VGND VGND VPWR VPWR sky130_fd_sc_hd__fill_1
XPHY_EDGE_ROW_53_Left_160 VGND VGND VPWR VPWR sky130_fd_sc_hd__decap_3
XTAP_TAPCELL_ROW_44_719 VGND VPWR sky130_fd_sc_hd__tapvpwrvgnd_1
XTAP_TAPCELL_ROW_105_1390 VGND VPWR sky130_fd_sc_hd__tapvpwrvgnd_1
XFILLER_41_289 VPWR VGND VPWR VGND sky130_ef_sc_hd__decap_12
XTAP_TAPCELL_ROW_24_498 VGND VPWR sky130_fd_sc_hd__tapvpwrvgnd_1
XFILLER_6_625 VGND VGND VPWR VPWR sky130_fd_sc_hd__decap_4
XFILLER_5_146 VGND VGND VPWR VPWR sky130_fd_sc_hd__decap_3
XFILLER_89_481 VPWR VGND VPWR VGND sky130_ef_sc_hd__decap_12
XFILLER_1_385 VGND VGND VPWR VPWR sky130_fd_sc_hd__decap_6
XFILLER_94_41 VPWR VGND VPWR VGND sky130_ef_sc_hd__decap_12
XFILLER_37_518 VGND VGND VPWR VPWR sky130_fd_sc_hd__fill_1
XFILLER_94_85 VPWR VGND VPWR VGND sky130_ef_sc_hd__decap_12
XFILLER_76_197 VGND VGND VPWR VPWR sky130_fd_sc_hd__decap_3
XFILLER_45_540 VGND VGND VPWR VPWR sky130_fd_sc_hd__fill_2
XFILLER_17_297 VGND VGND VPWR VPWR sky130_fd_sc_hd__fill_2
X_3750_ _1163_ _1231_ _1126_ VGND VGND VPWR VPWR _1232_ sky130_fd_sc_hd__a21oi_1
XFILLER_60_587 VGND VGND VPWR VPWR sky130_fd_sc_hd__fill_1
XFILLER_9_441 VGND VGND VPWR VPWR sky130_fd_sc_hd__decap_6
X_2701_ net511 net299 net232 VGND VGND VPWR VPWR _0225_ sky130_fd_sc_hd__mux2_1
XFILLER_9_485 VPWR VGND VPWR VGND sky130_ef_sc_hd__decap_12
X_3681_ _1161_ _1162_ VGND VGND VPWR VPWR _1163_ sky130_fd_sc_hd__and2_1
X_2632_ lsu.store_fifo.w_ptr\[0\] _1445_ VGND VGND VPWR VPWR _2008_ sky130_fd_sc_hd__nor2_1
XFILLER_64_3 VGND VGND VPWR VPWR sky130_fd_sc_hd__fill_1
X_2563_ net27 net259 _1958_ _1959_ VGND VGND VPWR VPWR _1960_ sky130_fd_sc_hd__a22o_1
XFILLER_99_223 VGND VGND VPWR VPWR sky130_fd_sc_hd__fill_1
X_4302_ clknet_leaf_55_clk _0359_ VGND VGND VPWR VPWR lsu.load_fifo.queue\[10\]\[8\]
+ sky130_fd_sc_hd__dfxtp_1
XFILLER_99_278 VGND VGND VPWR VPWR sky130_fd_sc_hd__fill_2
X_2494_ net80 net266 VGND VGND VPWR VPWR _1909_ sky130_fd_sc_hd__nand2_1
X_4233_ clknet_leaf_70_clk _0290_ VGND VGND VPWR VPWR lsu.store_fifo.queue\[3\]\[1\]
+ sky130_fd_sc_hd__dfxtp_1
XFILLER_4_83 VGND VGND VPWR VPWR sky130_fd_sc_hd__fill_1
XFILLER_95_440 VGND VGND VPWR VPWR sky130_fd_sc_hd__decap_8
X_4164_ clknet_leaf_30_clk _0221_ VGND VGND VPWR VPWR lsu.load_fifo.queue\[11\]\[24\]
+ sky130_fd_sc_hd__dfxtp_1
XFILLER_67_142 VGND VGND VPWR VPWR sky130_fd_sc_hd__fill_1
X_3115_ net725 net336 net181 VGND VGND VPWR VPWR _0618_ sky130_fd_sc_hd__mux2_1
X_4095_ net1242 net247 _1527_ VGND VGND VPWR VPWR _0994_ sky130_fd_sc_hd__o21a_1
X_3046_ net928 net343 net206 VGND VGND VPWR VPWR _0551_ sky130_fd_sc_hd__mux2_1
XFILLER_55_337 VGND VGND VPWR VPWR sky130_fd_sc_hd__decap_3
XFILLER_67_186 VGND VGND VPWR VPWR sky130_fd_sc_hd__fill_2
XFILLER_11_429 VPWR VGND VPWR VGND sky130_ef_sc_hd__decap_12
X_4997_ clknet_leaf_2_clk _1052_ VGND VGND VPWR VPWR lsu.load_fifo.queue\[14\]\[18\]
+ sky130_fd_sc_hd__dfxtp_1
XTAP_TAPCELL_ROW_98_1312 VGND VPWR sky130_fd_sc_hd__tapvpwrvgnd_1
X_3948_ _1394_ _1395_ net365 VGND VGND VPWR VPWR _1396_ sky130_fd_sc_hd__mux2_1
XTAP_TAPCELL_ROW_21_457 VGND VPWR sky130_fd_sc_hd__tapvpwrvgnd_1
X_3879_ lsu.load_fifo.queue\[0\]\[17\] lsu.load_fifo.queue\[1\]\[17\] lsu.load_fifo.queue\[2\]\[17\]
+ lsu.load_fifo.queue\[3\]\[17\] net388 net371 VGND VGND VPWR VPWR _1337_ sky130_fd_sc_hd__mux4_1
XFILLER_3_617 VPWR VGND VPWR VGND sky130_ef_sc_hd__decap_12
XFILLER_2_127 VPWR VGND VPWR VGND sky130_ef_sc_hd__decap_12
XFILLER_105_556 VGND VGND VPWR VPWR sky130_fd_sc_hd__decap_4
Xfanout431 net433 VGND VGND VPWR VPWR net431 sky130_fd_sc_hd__buf_4
Xfanout420 lsu.store_fifo.w_ptr\[1\] VGND VGND VPWR VPWR net420 sky130_fd_sc_hd__buf_2
Xfanout442 net445 VGND VGND VPWR VPWR net442 sky130_fd_sc_hd__buf_2
XFILLER_19_529 VGND VGND VPWR VPWR sky130_fd_sc_hd__decap_4
XTAP_TAPCELL_ROW_29_546 VGND VPWR sky130_fd_sc_hd__tapvpwrvgnd_1
XTAP_TAPCELL_ROW_57_855 VGND VPWR sky130_fd_sc_hd__tapvpwrvgnd_1
XFILLER_73_145 VGND VGND VPWR VPWR sky130_fd_sc_hd__fill_2
XFILLER_6_433 VPWR VGND VPWR VGND sky130_ef_sc_hd__decap_12
XFILLER_6_477 VPWR VGND VPWR VGND sky130_ef_sc_hd__decap_12
XTAP_TAPCELL_ROW_71_1006 VGND VPWR sky130_fd_sc_hd__tapvpwrvgnd_1
XFILLER_29_6 VGND VGND VPWR VPWR sky130_fd_sc_hd__decap_8
XFILLER_64_101 VGND VGND VPWR VPWR sky130_fd_sc_hd__decap_6
XFILLER_37_337 VGND VGND VPWR VPWR sky130_fd_sc_hd__fill_1
XFILLER_18_562 VPWR VGND VPWR VGND sky130_ef_sc_hd__decap_12
XFILLER_33_521 VGND VGND VPWR VPWR sky130_fd_sc_hd__fill_2
X_4920_ clknet_leaf_12_clk _0975_ VGND VGND VPWR VPWR lsu.load_fifo.queue\[13\]\[15\]
+ sky130_fd_sc_hd__dfxtp_1
X_4851_ clknet_leaf_37_clk _0906_ _0101_ VGND VGND VPWR VPWR lsu.load_counter\[1\]
+ sky130_fd_sc_hd__dfrtp_1
XTAP_TAPCELL_ROW_82_1135 VGND VPWR sky130_fd_sc_hd__tapvpwrvgnd_1
X_3802_ lsu.load_fifo.queue\[4\]\[28\] lsu.load_fifo.queue\[5\]\[28\] lsu.load_fifo.queue\[6\]\[28\]
+ lsu.load_fifo.queue\[7\]\[28\] net393 net376 VGND VGND VPWR VPWR _1271_ sky130_fd_sc_hd__mux4_1
X_4782_ clknet_leaf_57_clk _0839_ VGND VGND VPWR VPWR lsu.store_fifo.queue\[0\]\[2\]
+ sky130_fd_sc_hd__dfxtp_1
XFILLER_9_260 VGND VGND VPWR VPWR sky130_fd_sc_hd__decap_4
X_3733_ acc.byte3\[0\] acc.byte2\[0\] VGND VGND VPWR VPWR _1215_ sky130_fd_sc_hd__or2_1
X_3664_ acc.byte1\[2\] acc.byte0\[2\] VGND VGND VPWR VPWR _1146_ sky130_fd_sc_hd__or2_1
XFILLER_106_309 VGND VGND VPWR VPWR sky130_fd_sc_hd__fill_2
Xclkload30 clknet_leaf_15_clk VGND VGND VPWR VPWR clkload30/Y sky130_fd_sc_hd__bufinv_16
X_2615_ net412 net246 VGND VGND VPWR VPWR _0713_ sky130_fd_sc_hd__xor2_1
Xclkload52 clknet_leaf_57_clk VGND VGND VPWR VPWR clkload52/Y sky130_fd_sc_hd__clkinv_8
Xclkload41 clknet_leaf_11_clk VGND VGND VPWR VPWR clkload41/X sky130_fd_sc_hd__clkbuf_4
Xclkload74 clknet_leaf_52_clk VGND VGND VPWR VPWR clkload74/Y sky130_fd_sc_hd__inv_8
Xclkload63 clknet_leaf_63_clk VGND VGND VPWR VPWR clkload63/Y sky130_fd_sc_hd__clkinvlp_4
X_3595_ net423 VGND VGND VPWR VPWR _0159_ sky130_fd_sc_hd__inv_2
Xclkload85 clknet_leaf_51_clk VGND VGND VPWR VPWR clkload85/Y sky130_fd_sc_hd__inv_8
X_2546_ lsu.current_load_addr\[16\] _1929_ net260 VGND VGND VPWR VPWR _1947_ sky130_fd_sc_hd__a21oi_1
XTAP_TAPCELL_ROW_93_1253 VGND VPWR sky130_fd_sc_hd__tapvpwrvgnd_1
X_2477_ lsu.current_store_addr\[6\] net238 _1897_ VGND VGND VPWR VPWR _0795_ sky130_fd_sc_hd__o21a_1
XFILLER_87_237 VGND VGND VPWR VPWR sky130_fd_sc_hd__decap_3
X_4216_ clknet_leaf_56_clk _0273_ VGND VGND VPWR VPWR lsu.store_fifo.queue\[5\]\[4\]
+ sky130_fd_sc_hd__dfxtp_1
XFILLER_68_451 VGND VGND VPWR VPWR sky130_fd_sc_hd__fill_1
XFILLER_18_26 VGND VGND VPWR VPWR sky130_fd_sc_hd__fill_2
X_4147_ clknet_leaf_14_clk _0204_ VGND VGND VPWR VPWR lsu.load_fifo.queue\[11\]\[7\]
+ sky130_fd_sc_hd__dfxtp_1
XFILLER_95_281 VPWR VGND VPWR VGND sky130_ef_sc_hd__decap_12
XFILLER_83_432 VPWR VGND VPWR VGND sky130_ef_sc_hd__decap_12
X_4078_ lsu.store_fifo.queue\[4\]\[3\] lsu.store_fifo.queue\[5\]\[3\] lsu.store_fifo.queue\[6\]\[3\]
+ lsu.store_fifo.queue\[7\]\[3\] net411 net406 VGND VGND VPWR VPWR _1512_ sky130_fd_sc_hd__mux4_1
XFILLER_83_498 VGND VGND VPWR VPWR sky130_fd_sc_hd__decap_6
XTAP_TAPCELL_ROW_26_516 VGND VPWR sky130_fd_sc_hd__tapvpwrvgnd_1
X_3029_ net876 net310 net211 VGND VGND VPWR VPWR _0535_ sky130_fd_sc_hd__mux2_1
XTAP_TAPCELL_ROW_54_825 VGND VPWR sky130_fd_sc_hd__tapvpwrvgnd_1
XFILLER_24_587 VGND VGND VPWR VPWR sky130_fd_sc_hd__fill_1
XFILLER_11_237 VGND VGND VPWR VPWR sky130_fd_sc_hd__fill_1
Xclkload2 clknet_3_3__leaf_clk VGND VGND VPWR VPWR clkload2/Y sky130_fd_sc_hd__clkinvlp_4
XFILLER_3_447 VGND VGND VPWR VPWR sky130_fd_sc_hd__fill_1
Xfanout250 _2054_ VGND VGND VPWR VPWR net250 sky130_fd_sc_hd__buf_4
Xfanout261 _1548_ VGND VGND VPWR VPWR net261 sky130_fd_sc_hd__dlymetal6s2s_1
Xfanout272 acc.data_out\[9\] VGND VGND VPWR VPWR net272 sky130_fd_sc_hd__buf_2
Xfanout283 acc.data_out\[4\] VGND VGND VPWR VPWR net283 sky130_fd_sc_hd__buf_1
XFILLER_74_421 VPWR VGND VPWR VGND sky130_ef_sc_hd__decap_12
XTAP_TAPCELL_ROW_6_296 VGND VPWR sky130_fd_sc_hd__tapvpwrvgnd_1
XFILLER_19_326 VGND VGND VPWR VPWR sky130_fd_sc_hd__decap_8
XFILLER_19_337 VGND VGND VPWR VPWR sky130_fd_sc_hd__decap_8
Xfanout294 lsu.load_fifo.data_in\[30\] VGND VGND VPWR VPWR net294 sky130_fd_sc_hd__clkbuf_2
XFILLER_46_167 VGND VGND VPWR VPWR sky130_fd_sc_hd__decap_3
Xhold709 lsu.store_fifo.queue\[0\]\[4\] VGND VGND VPWR VPWR net1177 sky130_fd_sc_hd__dlygate4sd3_1
X_2400_ lsu.storer_state\[2\] lsu.storer_state\[1\] VGND VGND VPWR VPWR _1837_ sky130_fd_sc_hd__and2b_1
X_3380_ net296 net974 net171 VGND VGND VPWR VPWR _0989_ sky130_fd_sc_hd__mux2_1
XFILLER_97_513 VGND VGND VPWR VPWR sky130_fd_sc_hd__fill_1
X_2331_ lsu.load_fifo.w_ptr\[1\] lsu.load_fifo.w_ptr\[0\] _1253_ VGND VGND VPWR VPWR
+ _1771_ sky130_fd_sc_hd__a21o_1
X_2262_ lsu.store_counter\[5\] lsu.store_counter\[4\] _1726_ VGND VGND VPWR VPWR _1727_
+ sky130_fd_sc_hd__and3_1
XFILLER_27_3 VGND VGND VPWR VPWR sky130_fd_sc_hd__decap_6
X_4001_ net405 lsu.store_fifo.w_ptr\[2\] VGND VGND VPWR VPWR _1441_ sky130_fd_sc_hd__xor2_1
X_2193_ net168 net164 _1676_ net263 net245 VGND VGND VPWR VPWR _1681_ sky130_fd_sc_hd__o221a_1
XFILLER_92_251 VGND VGND VPWR VPWR sky130_fd_sc_hd__fill_1
XFILLER_1_51 VGND VGND VPWR VPWR sky130_fd_sc_hd__decap_4
XPHY_EDGE_ROW_9_Left_116 VGND VGND VPWR VPWR sky130_fd_sc_hd__decap_3
XFILLER_80_468 VGND VGND VPWR VPWR sky130_fd_sc_hd__decap_8
X_4903_ clknet_leaf_12_clk _0958_ VGND VGND VPWR VPWR lsu.load_fifo.queue\[12\]\[30\]
+ sky130_fd_sc_hd__dfxtp_1
X_4834_ clknet_leaf_45_clk _0891_ _0084_ VGND VGND VPWR VPWR lsu.store_counter\[11\]
+ sky130_fd_sc_hd__dfrtp_1
XFILLER_33_384 VGND VGND VPWR VPWR sky130_fd_sc_hd__fill_2
X_4765_ clknet_leaf_44_clk net776 VGND VGND VPWR VPWR net129 sky130_fd_sc_hd__dfxtp_1
XTAP_TAPCELL_ROW_31_574 VGND VPWR sky130_fd_sc_hd__tapvpwrvgnd_1
X_3716_ acc.byte3\[2\] acc.byte2\[2\] VGND VGND VPWR VPWR _1198_ sky130_fd_sc_hd__nand2_1
X_4696_ clknet_leaf_49_clk _0753_ VGND VGND VPWR VPWR lsu.store_fifo.queue\[14\]\[0\]
+ sky130_fd_sc_hd__dfxtp_1
XFILLER_106_128 VGND VGND VPWR VPWR sky130_fd_sc_hd__fill_1
X_3647_ _1127_ _1128_ VGND VGND VPWR VPWR _1129_ sky130_fd_sc_hd__nand2b_1
X_3578_ net422 VGND VGND VPWR VPWR _0142_ sky130_fd_sc_hd__inv_2
X_2529_ net477 _1933_ _1934_ net1284 VGND VGND VPWR VPWR _0748_ sky130_fd_sc_hd__o2bb2a_1
XFILLER_88_513 VPWR VGND VPWR VGND sky130_ef_sc_hd__decap_12
XFILLER_0_417 VGND VGND VPWR VPWR sky130_fd_sc_hd__decap_3
XFILLER_29_14 VGND VGND VPWR VPWR sky130_fd_sc_hd__fill_1
Xhold36 lsu.load_fifo.queue\[2\]\[2\] VGND VGND VPWR VPWR net504 sky130_fd_sc_hd__dlygate4sd3_1
Xhold47 lsu.load_fifo.queue\[7\]\[31\] VGND VGND VPWR VPWR net515 sky130_fd_sc_hd__dlygate4sd3_1
XFILLER_29_47 VGND VGND VPWR VPWR sky130_fd_sc_hd__fill_1
Xhold69 lsu.load_fifo.queue\[12\]\[9\] VGND VGND VPWR VPWR net537 sky130_fd_sc_hd__dlygate4sd3_1
XFILLER_56_421 VGND VGND VPWR VPWR sky130_fd_sc_hd__decap_4
Xhold58 lsu.load_fifo.queue\[6\]\[12\] VGND VGND VPWR VPWR net526 sky130_fd_sc_hd__dlygate4sd3_1
XFILLER_83_240 VGND VGND VPWR VPWR sky130_fd_sc_hd__fill_1
XTAP_TAPCELL_ROW_3_266 VGND VPWR sky130_fd_sc_hd__tapvpwrvgnd_1
XTAP_TAPCELL_ROW_67_972 VGND VPWR sky130_fd_sc_hd__tapvpwrvgnd_1
XTAP_TAPCELL_ROW_39_663 VGND VPWR sky130_fd_sc_hd__tapvpwrvgnd_1
XFILLER_71_446 VGND VGND VPWR VPWR sky130_fd_sc_hd__fill_2
XFILLER_101_30 VPWR VGND VPWR VGND sky130_ef_sc_hd__decap_12
XFILLER_12_513 VPWR VGND VPWR VGND sky130_ef_sc_hd__decap_12
XFILLER_12_557 VPWR VGND VPWR VGND sky130_ef_sc_hd__decap_12
XFILLER_6_29 VGND VGND VPWR VPWR sky130_fd_sc_hd__decap_8
XFILLER_3_233 VGND VGND VPWR VPWR sky130_fd_sc_hd__decap_8
XFILLER_3_277 VGND VGND VPWR VPWR sky130_fd_sc_hd__decap_3
XFILLER_94_549 VGND VGND VPWR VPWR sky130_fd_sc_hd__fill_2
XFILLER_59_281 VGND VGND VPWR VPWR sky130_fd_sc_hd__decap_4
XFILLER_34_104 VGND VGND VPWR VPWR sky130_fd_sc_hd__decap_4
XFILLER_62_446 VGND VGND VPWR VPWR sky130_fd_sc_hd__decap_4
X_2880_ net1070 net338 net196 VGND VGND VPWR VPWR _0391_ sky130_fd_sc_hd__mux2_1
X_4550_ clknet_leaf_11_clk _0607_ VGND VGND VPWR VPWR lsu.load_fifo.queue\[1\]\[30\]
+ sky130_fd_sc_hd__dfxtp_1
X_3501_ net444 VGND VGND VPWR VPWR _0065_ sky130_fd_sc_hd__inv_2
Xhold506 lsu.load_fifo.queue\[13\]\[29\] VGND VGND VPWR VPWR net974 sky130_fd_sc_hd__dlygate4sd3_1
X_4481_ clknet_leaf_68_clk _0538_ VGND VGND VPWR VPWR lsu.load_fifo.queue\[3\]\[25\]
+ sky130_fd_sc_hd__dfxtp_1
XFILLER_7_561 VPWR VGND VPWR VGND sky130_ef_sc_hd__decap_12
Xhold517 lsu.load_fifo.queue\[1\]\[13\] VGND VGND VPWR VPWR net985 sky130_fd_sc_hd__dlygate4sd3_1
Xmax_cap236 _1652_ VGND VGND VPWR VPWR net236 sky130_fd_sc_hd__clkbuf_1
XTAP_TAPCELL_ROW_77_1078 VGND VPWR sky130_fd_sc_hd__tapvpwrvgnd_1
Xhold539 lsu.load_fifo.queue\[3\]\[6\] VGND VGND VPWR VPWR net1007 sky130_fd_sc_hd__dlygate4sd3_1
Xhold528 lsu.store_fifo.queue\[1\]\[1\] VGND VGND VPWR VPWR net996 sky130_fd_sc_hd__dlygate4sd3_1
X_3432_ net824 net283 _2059_ VGND VGND VPWR VPWR _1090_ sky130_fd_sc_hd__mux2_1
XTAP_TAPCELL_ROW_90_1223 VGND VPWR sky130_fd_sc_hd__tapvpwrvgnd_1
X_3363_ net331 net713 net171 VGND VGND VPWR VPWR _0972_ sky130_fd_sc_hd__mux2_1
XFILLER_97_365 VGND VGND VPWR VPWR sky130_fd_sc_hd__fill_2
XFILLER_85_505 VGND VGND VPWR VPWR sky130_fd_sc_hd__fill_2
X_2314_ lsu.store_counter\[6\] _1761_ _1762_ _1727_ VGND VGND VPWR VPWR _0886_ sky130_fd_sc_hd__a22o_1
X_3294_ net336 net78 net248 VGND VGND VPWR VPWR _0856_ sky130_fd_sc_hd__mux2_1
X_2245_ lsu.acc_state\[0\] acc.done VGND VGND VPWR VPWR _1712_ sky130_fd_sc_hd__nor2_1
X_5033_ clknet_leaf_62_clk _1088_ VGND VGND VPWR VPWR lsu.store_fifo.queue\[12\]\[2\]
+ sky130_fd_sc_hd__dfxtp_1
X_2176_ net163 net166 net243 VGND VGND VPWR VPWR _1666_ sky130_fd_sc_hd__o21a_4
XFILLER_93_582 VGND VGND VPWR VPWR sky130_fd_sc_hd__fill_2
XTAP_TAPCELL_ROW_0_214 VGND VPWR sky130_fd_sc_hd__tapvpwrvgnd_1
XTAP_TAPCELL_ROW_0_225 VGND VPWR sky130_fd_sc_hd__tapvpwrvgnd_1
XFILLER_65_262 VGND VGND VPWR VPWR sky130_fd_sc_hd__decap_4
XTAP_TAPCELL_ROW_88_1196 VGND VPWR sky130_fd_sc_hd__tapvpwrvgnd_1
XTAP_TAPCELL_ROW_36_622 VGND VPWR sky130_fd_sc_hd__tapvpwrvgnd_1
XTAP_TAPCELL_ROW_64_931 VGND VPWR sky130_fd_sc_hd__tapvpwrvgnd_1
XFILLER_15_49 VGND VGND VPWR VPWR sky130_fd_sc_hd__decap_6
X_4817_ clknet_leaf_81_clk _0874_ VGND VGND VPWR VPWR lsu.load_fifo.data_in\[27\]
+ sky130_fd_sc_hd__dfxtp_1
Xclkbuf_leaf_60_clk clknet_3_5__leaf_clk VGND VGND VPWR VPWR clknet_leaf_60_clk sky130_fd_sc_hd__clkbuf_8
X_4748_ clknet_leaf_47_clk _0805_ _0062_ VGND VGND VPWR VPWR lsu.current_store_addr\[16\]
+ sky130_fd_sc_hd__dfrtp_1
X_4679_ clknet_leaf_29_clk _0736_ _0025_ VGND VGND VPWR VPWR lsu.current_load_addr\[9\]
+ sky130_fd_sc_hd__dfrtp_1
XPHY_EDGE_ROW_1_Right_1 VGND VGND VPWR VPWR sky130_fd_sc_hd__decap_3
XTAP_TAPCELL_ROW_8_314 VGND VPWR sky130_fd_sc_hd__tapvpwrvgnd_1
XFILLER_0_225 VPWR VGND VPWR VGND sky130_ef_sc_hd__decap_12
XFILLER_88_365 VPWR VGND VPWR VGND sky130_ef_sc_hd__decap_12
XFILLER_48_207 VGND VGND VPWR VPWR sky130_fd_sc_hd__decap_6
XFILLER_56_240 VGND VGND VPWR VPWR sky130_fd_sc_hd__decap_3
XFILLER_31_129 VGND VGND VPWR VPWR sky130_fd_sc_hd__decap_3
Xclkbuf_leaf_51_clk clknet_3_7__leaf_clk VGND VGND VPWR VPWR clknet_leaf_51_clk sky130_fd_sc_hd__clkbuf_8
XFILLER_8_358 VGND VGND VPWR VPWR sky130_fd_sc_hd__decap_6
XFILLER_4_531 VGND VGND VPWR VPWR sky130_fd_sc_hd__fill_1
XFILLER_106_470 VGND VGND VPWR VPWR sky130_fd_sc_hd__fill_2
XFILLER_106_492 VGND VGND VPWR VPWR sky130_fd_sc_hd__fill_1
XFILLER_79_387 VGND VGND VPWR VPWR sky130_fd_sc_hd__decap_4
X_3981_ net1268 _1424_ net253 VGND VGND VPWR VPWR _1005_ sky130_fd_sc_hd__mux2_1
XFILLER_50_405 VGND VGND VPWR VPWR sky130_fd_sc_hd__fill_1
XTAP_TAPCELL_ROW_61_901 VGND VPWR sky130_fd_sc_hd__tapvpwrvgnd_1
XPHY_EDGE_ROW_99_Left_206 VGND VGND VPWR VPWR sky130_fd_sc_hd__decap_3
X_2932_ net789 net300 net219 VGND VGND VPWR VPWR _0444_ sky130_fd_sc_hd__mux2_1
Xclkbuf_leaf_42_clk clknet_3_7__leaf_clk VGND VGND VPWR VPWR clknet_leaf_42_clk sky130_fd_sc_hd__clkbuf_8
XFILLER_94_3 VPWR VGND VPWR VGND sky130_ef_sc_hd__decap_12
X_2863_ net1103 net308 net223 VGND VGND VPWR VPWR _0374_ sky130_fd_sc_hd__mux2_1
XTAP_TAPCELL_ROW_13_371 VGND VPWR sky130_fd_sc_hd__tapvpwrvgnd_1
X_4602_ clknet_leaf_84_clk _0659_ VGND VGND VPWR VPWR lsu.load_fifo.queue\[8\]\[18\]
+ sky130_fd_sc_hd__dfxtp_1
XTAP_TAPCELL_ROW_41_680 VGND VPWR sky130_fd_sc_hd__tapvpwrvgnd_1
X_2794_ net420 _2012_ _2029_ VGND VGND VPWR VPWR _2032_ sky130_fd_sc_hd__or3_4
X_4533_ clknet_leaf_6_clk _0590_ VGND VGND VPWR VPWR lsu.load_fifo.queue\[1\]\[13\]
+ sky130_fd_sc_hd__dfxtp_1
Xhold325 net138 VGND VGND VPWR VPWR net793 sky130_fd_sc_hd__dlygate4sd3_1
Xhold303 lsu.store_fifo.queue\[4\]\[2\] VGND VGND VPWR VPWR net771 sky130_fd_sc_hd__dlygate4sd3_1
Xhold314 lsu.load_fifo.queue\[7\]\[30\] VGND VGND VPWR VPWR net782 sky130_fd_sc_hd__dlygate4sd3_1
Xhold358 lsu.load_fifo.queue\[14\]\[6\] VGND VGND VPWR VPWR net826 sky130_fd_sc_hd__dlygate4sd3_1
Xhold347 lsu.load_fifo.queue\[8\]\[27\] VGND VGND VPWR VPWR net815 sky130_fd_sc_hd__dlygate4sd3_1
Xhold336 lsu.load_fifo.queue\[0\]\[14\] VGND VGND VPWR VPWR net804 sky130_fd_sc_hd__dlygate4sd3_1
Xhold369 lsu.store_fifo.queue\[2\]\[5\] VGND VGND VPWR VPWR net837 sky130_fd_sc_hd__dlygate4sd3_1
X_4464_ clknet_leaf_34_clk _0521_ VGND VGND VPWR VPWR lsu.load_fifo.queue\[3\]\[8\]
+ sky130_fd_sc_hd__dfxtp_1
X_4395_ clknet_leaf_87_clk _0452_ VGND VGND VPWR VPWR lsu.load_fifo.queue\[5\]\[3\]
+ sky130_fd_sc_hd__dfxtp_1
X_3415_ net879 net293 net199 VGND VGND VPWR VPWR _1065_ sky130_fd_sc_hd__mux2_1
X_3346_ net669 net299 net175 VGND VGND VPWR VPWR _0956_ sky130_fd_sc_hd__mux2_1
XFILLER_85_357 VPWR VGND VPWR VGND sky130_ef_sc_hd__decap_12
X_3277_ net873 net285 _2053_ VGND VGND VPWR VPWR _0840_ sky130_fd_sc_hd__mux2_1
X_5016_ clknet_leaf_59_clk _1071_ VGND VGND VPWR VPWR lsu.store_fifo.queue\[13\]\[5\]
+ sky130_fd_sc_hd__dfxtp_1
X_2228_ net479 net165 _1669_ net262 net245 VGND VGND VPWR VPWR _1702_ sky130_fd_sc_hd__o221a_1
XFILLER_38_251 VGND VGND VPWR VPWR sky130_fd_sc_hd__fill_1
X_2159_ _1610_ _1611_ _1614_ _1608_ _1604_ VGND VGND VPWR VPWR _1649_ sky130_fd_sc_hd__o32a_1
XFILLER_41_438 VGND VGND VPWR VPWR sky130_fd_sc_hd__fill_1
Xclkbuf_leaf_33_clk clknet_3_3__leaf_clk VGND VGND VPWR VPWR clknet_leaf_33_clk sky130_fd_sc_hd__clkbuf_8
XFILLER_103_462 VGND VGND VPWR VPWR sky130_fd_sc_hd__fill_2
XFILLER_88_173 VGND VGND VPWR VPWR sky130_fd_sc_hd__decap_3
XFILLER_91_349 VPWR VGND VPWR VGND sky130_ef_sc_hd__decap_12
XFILLER_44_210 VGND VGND VPWR VPWR sky130_fd_sc_hd__decap_3
XFILLER_16_70 VGND VGND VPWR VPWR sky130_fd_sc_hd__fill_2
XFILLER_44_298 VGND VGND VPWR VPWR sky130_fd_sc_hd__decap_8
Xclkbuf_leaf_24_clk clknet_3_2__leaf_clk VGND VGND VPWR VPWR clknet_leaf_24_clk sky130_fd_sc_hd__clkbuf_8
XFILLER_16_81 VGND VGND VPWR VPWR sky130_fd_sc_hd__decap_3
Xlsu_wrapper_455 VGND VGND VPWR VPWR lsu_wrapper_455/HI store_data[18] sky130_fd_sc_hd__conb_1
Xlsu_wrapper_466 VGND VGND VPWR VPWR lsu_wrapper_466/HI store_data[29] sky130_fd_sc_hd__conb_1
XTAP_TAPCELL_ROW_10_341 VGND VPWR sky130_fd_sc_hd__tapvpwrvgnd_1
XTAP_TAPCELL_ROW_74_1048 VGND VPWR sky130_fd_sc_hd__tapvpwrvgnd_1
X_4180_ clknet_leaf_60_clk _0237_ VGND VGND VPWR VPWR lsu.store_fifo.queue\[9\]\[8\]
+ sky130_fd_sc_hd__dfxtp_1
X_3200_ net633 net298 net204 VGND VGND VPWR VPWR _0701_ sky130_fd_sc_hd__mux2_1
XFILLER_67_324 VPWR VGND VPWR VGND sky130_ef_sc_hd__decap_12
X_3131_ net886 net304 net182 VGND VGND VPWR VPWR _0634_ sky130_fd_sc_hd__mux2_1
XFILLER_94_121 VPWR VGND VPWR VGND sky130_ef_sc_hd__decap_12
XFILLER_94_176 VPWR VGND VPWR VGND sky130_ef_sc_hd__decap_12
X_3062_ net759 net311 net207 VGND VGND VPWR VPWR _0567_ sky130_fd_sc_hd__mux2_1
XFILLER_75_390 VGND VGND VPWR VPWR sky130_fd_sc_hd__fill_2
XFILLER_35_221 VGND VGND VPWR VPWR sky130_fd_sc_hd__decap_3
XFILLER_63_530 VGND VGND VPWR VPWR sky130_fd_sc_hd__decap_6
XTAP_TAPCELL_ROW_85_1166 VGND VPWR sky130_fd_sc_hd__tapvpwrvgnd_1
XTAP_TAPCELL_ROW_18_430 VGND VPWR sky130_fd_sc_hd__tapvpwrvgnd_1
Xclkbuf_leaf_15_clk clknet_3_2__leaf_clk VGND VGND VPWR VPWR clknet_leaf_15_clk sky130_fd_sc_hd__clkbuf_8
XFILLER_23_449 VGND VGND VPWR VPWR sky130_fd_sc_hd__decap_4
X_3964_ lsu.load_fifo.queue\[12\]\[5\] lsu.load_fifo.queue\[13\]\[5\] lsu.load_fifo.queue\[14\]\[5\]
+ lsu.load_fifo.queue\[15\]\[5\] net391 net374 VGND VGND VPWR VPWR _1410_ sky130_fd_sc_hd__mux4_1
XFILLER_50_257 VGND VGND VPWR VPWR sky130_fd_sc_hd__fill_1
X_2915_ net580 net334 net220 VGND VGND VPWR VPWR _0427_ sky130_fd_sc_hd__mux2_1
X_3895_ _1350_ _1349_ net363 VGND VGND VPWR VPWR _1351_ sky130_fd_sc_hd__mux2_1
X_2846_ net1046 net343 net222 VGND VGND VPWR VPWR _0357_ sky130_fd_sc_hd__mux2_1
Xhold100 lsu.load_fifo.queue\[4\]\[23\] VGND VGND VPWR VPWR net568 sky130_fd_sc_hd__dlygate4sd3_1
X_2777_ net282 net1039 _2030_ VGND VGND VPWR VPWR _0293_ sky130_fd_sc_hd__mux2_1
XTAP_TAPCELL_ROW_96_1284 VGND VPWR sky130_fd_sc_hd__tapvpwrvgnd_1
Xhold144 lsu.load_fifo.queue\[10\]\[10\] VGND VGND VPWR VPWR net612 sky130_fd_sc_hd__dlygate4sd3_1
Xhold111 lsu.load_fifo.queue\[0\]\[28\] VGND VGND VPWR VPWR net579 sky130_fd_sc_hd__dlygate4sd3_1
XFILLER_2_309 VGND VGND VPWR VPWR sky130_fd_sc_hd__decap_3
Xhold122 lsu.load_fifo.queue\[11\]\[4\] VGND VGND VPWR VPWR net590 sky130_fd_sc_hd__dlygate4sd3_1
Xhold133 lsu.load_fifo.queue\[15\]\[4\] VGND VGND VPWR VPWR net601 sky130_fd_sc_hd__dlygate4sd3_1
X_4516_ clknet_leaf_15_clk _0573_ VGND VGND VPWR VPWR lsu.load_fifo.queue\[2\]\[28\]
+ sky130_fd_sc_hd__dfxtp_1
Xhold155 net104 VGND VGND VPWR VPWR net623 sky130_fd_sc_hd__dlygate4sd3_1
Xhold166 lsu.load_fifo.queue\[4\]\[2\] VGND VGND VPWR VPWR net634 sky130_fd_sc_hd__dlygate4sd3_1
X_4447_ clknet_leaf_81_clk _0504_ VGND VGND VPWR VPWR lsu.load_fifo.queue\[4\]\[23\]
+ sky130_fd_sc_hd__dfxtp_1
Xhold177 lsu.store_fifo.queue\[2\]\[6\] VGND VGND VPWR VPWR net645 sky130_fd_sc_hd__dlygate4sd3_1
Xhold199 _0786_ VGND VGND VPWR VPWR net667 sky130_fd_sc_hd__dlygate4sd3_1
Xhold188 lsu.store_fifo.queue\[11\]\[5\] VGND VGND VPWR VPWR net656 sky130_fd_sc_hd__dlygate4sd3_1
X_4378_ clknet_leaf_1_clk _0435_ VGND VGND VPWR VPWR lsu.load_fifo.queue\[6\]\[18\]
+ sky130_fd_sc_hd__dfxtp_1
X_3329_ net777 net333 net173 VGND VGND VPWR VPWR _0939_ sky130_fd_sc_hd__mux2_1
XFILLER_26_210 VGND VGND VPWR VPWR sky130_fd_sc_hd__fill_1
XTAP_TAPCELL_ROW_44_709 VGND VPWR sky130_fd_sc_hd__tapvpwrvgnd_1
XFILLER_26_276 VGND VGND VPWR VPWR sky130_fd_sc_hd__fill_1
XTAP_TAPCELL_ROW_105_1380 VGND VPWR sky130_fd_sc_hd__tapvpwrvgnd_1
XFILLER_81_393 VGND VGND VPWR VPWR sky130_fd_sc_hd__decap_3
XTAP_TAPCELL_ROW_24_499 VGND VPWR sky130_fd_sc_hd__tapvpwrvgnd_1
XTAP_TAPCELL_ROW_52_797 VGND VPWR sky130_fd_sc_hd__tapvpwrvgnd_1
XFILLER_78_54 VGND VGND VPWR VPWR sky130_fd_sc_hd__decap_6
XFILLER_89_493 VGND VGND VPWR VPWR sky130_fd_sc_hd__decap_3
XFILLER_49_335 VGND VGND VPWR VPWR sky130_fd_sc_hd__fill_1
XFILLER_94_53 VPWR VGND VPWR VGND sky130_ef_sc_hd__decap_12
XFILLER_91_113 VPWR VGND VPWR VGND sky130_ef_sc_hd__decap_12
XFILLER_57_390 VGND VGND VPWR VPWR sky130_fd_sc_hd__fill_2
XFILLER_94_97 VPWR VGND VPWR VGND sky130_ef_sc_hd__decap_12
XFILLER_17_265 VGND VGND VPWR VPWR sky130_fd_sc_hd__decap_6
XTAP_TAPCELL_ROW_15_400 VGND VPWR sky130_fd_sc_hd__tapvpwrvgnd_1
X_2700_ net961 net301 net231 VGND VGND VPWR VPWR _0224_ sky130_fd_sc_hd__mux2_1
X_3680_ _1155_ _1160_ VGND VGND VPWR VPWR _1162_ sky130_fd_sc_hd__nand2_1
X_2631_ _1444_ _2006_ lsu.store_fifo.w_ptr\[0\] _1443_ VGND VGND VPWR VPWR _2007_
+ sky130_fd_sc_hd__o211a_1
XFILLER_9_497 VGND VGND VPWR VPWR sky130_fd_sc_hd__decap_6
X_2562_ net259 _1927_ VGND VGND VPWR VPWR _1959_ sky130_fd_sc_hd__nor2_1
XFILLER_57_3 VPWR VGND VPWR VGND sky130_ef_sc_hd__decap_12
X_4301_ clknet_leaf_14_clk _0358_ VGND VGND VPWR VPWR lsu.load_fifo.queue\[10\]\[7\]
+ sky130_fd_sc_hd__dfxtp_1
X_2493_ net252 _1907_ _1908_ net1277 VGND VGND VPWR VPWR _0790_ sky130_fd_sc_hd__o22a_1
X_4232_ clknet_leaf_53_clk _0289_ VGND VGND VPWR VPWR lsu.store_fifo.queue\[3\]\[0\]
+ sky130_fd_sc_hd__dfxtp_1
Xclkbuf_leaf_4_clk clknet_3_0__leaf_clk VGND VGND VPWR VPWR clknet_leaf_4_clk sky130_fd_sc_hd__clkbuf_8
X_4163_ clknet_leaf_80_clk _0220_ VGND VGND VPWR VPWR lsu.load_fifo.queue\[11\]\[23\]
+ sky130_fd_sc_hd__dfxtp_1
XFILLER_95_474 VGND VGND VPWR VPWR sky130_fd_sc_hd__decap_8
XFILLER_83_614 VGND VGND VPWR VPWR sky130_fd_sc_hd__fill_2
X_4094_ net247 _1526_ VGND VGND VPWR VPWR _1527_ sky130_fd_sc_hd__nand2_1
X_3114_ net517 net338 net184 VGND VGND VPWR VPWR _0617_ sky130_fd_sc_hd__mux2_1
X_3045_ net665 net345 net208 VGND VGND VPWR VPWR _0550_ sky130_fd_sc_hd__mux2_1
X_4996_ clknet_leaf_80_clk _1051_ VGND VGND VPWR VPWR lsu.load_fifo.queue\[14\]\[17\]
+ sky130_fd_sc_hd__dfxtp_1
X_3947_ lsu.load_fifo.queue\[12\]\[7\] lsu.load_fifo.queue\[13\]\[7\] lsu.load_fifo.queue\[14\]\[7\]
+ lsu.load_fifo.queue\[15\]\[7\] net396 net379 VGND VGND VPWR VPWR _1395_ sky130_fd_sc_hd__mux4_1
XTAP_TAPCELL_ROW_98_1313 VGND VPWR sky130_fd_sc_hd__tapvpwrvgnd_1
XTAP_TAPCELL_ROW_21_458 VGND VPWR sky130_fd_sc_hd__tapvpwrvgnd_1
X_3878_ lsu.load_fifo.queue\[4\]\[17\] lsu.load_fifo.queue\[5\]\[17\] lsu.load_fifo.queue\[6\]\[17\]
+ lsu.load_fifo.queue\[7\]\[17\] net388 net371 VGND VGND VPWR VPWR _1336_ sky130_fd_sc_hd__mux4_1
X_2829_ net308 net1088 net227 VGND VGND VPWR VPWR _0342_ sky130_fd_sc_hd__mux2_1
XFILLER_105_502 VGND VGND VPWR VPWR sky130_fd_sc_hd__fill_2
XFILLER_2_117 VGND VGND VPWR VPWR sky130_fd_sc_hd__fill_1
XFILLER_3_629 VGND VGND VPWR VPWR sky130_fd_sc_hd__fill_1
XFILLER_78_408 VGND VGND VPWR VPWR sky130_fd_sc_hd__fill_1
XFILLER_2_139 VGND VGND VPWR VPWR sky130_fd_sc_hd__fill_1
XFILLER_78_419 VGND VGND VPWR VPWR sky130_fd_sc_hd__fill_1
Xfanout410 lsu.store_fifo.r_ptr\[1\] VGND VGND VPWR VPWR net410 sky130_fd_sc_hd__clkbuf_4
Xfanout432 net433 VGND VGND VPWR VPWR net432 sky130_fd_sc_hd__buf_4
Xfanout443 net445 VGND VGND VPWR VPWR net443 sky130_fd_sc_hd__buf_4
XFILLER_100_251 VGND VGND VPWR VPWR sky130_fd_sc_hd__fill_1
XFILLER_104_41 VGND VGND VPWR VPWR sky130_fd_sc_hd__decap_8
XTAP_TAPCELL_ROW_29_547 VGND VPWR sky130_fd_sc_hd__tapvpwrvgnd_1
XTAP_TAPCELL_ROW_57_856 VGND VPWR sky130_fd_sc_hd__tapvpwrvgnd_1
XFILLER_27_585 VPWR VGND VPWR VGND sky130_ef_sc_hd__decap_12
XFILLER_42_522 VGND VGND VPWR VPWR sky130_fd_sc_hd__fill_1
XFILLER_6_445 VPWR VGND VPWR VGND sky130_ef_sc_hd__decap_12
XFILLER_6_489 VPWR VGND VPWR VGND sky130_ef_sc_hd__decap_12
XTAP_TAPCELL_ROW_71_1007 VGND VPWR sky130_fd_sc_hd__tapvpwrvgnd_1
XFILLER_77_452 VPWR VGND VPWR VGND sky130_ef_sc_hd__decap_12
XFILLER_92_477 VGND VGND VPWR VPWR sky130_fd_sc_hd__fill_2
Xclkbuf_3_7__f_clk clknet_0_clk VGND VGND VPWR VPWR clknet_3_7__leaf_clk sky130_fd_sc_hd__clkbuf_16
XFILLER_64_157 VGND VGND VPWR VPWR sky130_fd_sc_hd__fill_1
XFILLER_18_574 VPWR VGND VPWR VGND sky130_ef_sc_hd__decap_12
X_4850_ clknet_leaf_37_clk _0905_ _0100_ VGND VGND VPWR VPWR lsu.load_counter\[0\]
+ sky130_fd_sc_hd__dfrtp_2
XTAP_TAPCELL_ROW_82_1136 VGND VPWR sky130_fd_sc_hd__tapvpwrvgnd_1
X_3801_ net1270 _1270_ net254 VGND VGND VPWR VPWR _1031_ sky130_fd_sc_hd__mux2_1
XPHY_EDGE_ROW_72_Left_179 VGND VGND VPWR VPWR sky130_fd_sc_hd__decap_3
X_4781_ clknet_leaf_65_clk _0838_ VGND VGND VPWR VPWR lsu.store_fifo.queue\[0\]\[1\]
+ sky130_fd_sc_hd__dfxtp_1
X_3732_ acc.byte3\[0\] acc.byte2\[0\] VGND VGND VPWR VPWR _1214_ sky130_fd_sc_hd__nand2_1
X_3663_ _1142_ _1144_ _1141_ VGND VGND VPWR VPWR _1145_ sky130_fd_sc_hd__o21ai_2
Xclkload20 clknet_leaf_10_clk VGND VGND VPWR VPWR clkload20/Y sky130_fd_sc_hd__inv_8
Xclkload53 clknet_leaf_58_clk VGND VGND VPWR VPWR clkload53/Y sky130_fd_sc_hd__inv_12
X_2614_ _1992_ _1995_ VGND VGND VPWR VPWR _0714_ sky130_fd_sc_hd__nor2_1
Xclkload42 clknet_leaf_12_clk VGND VGND VPWR VPWR clkload42/Y sky130_fd_sc_hd__inv_6
Xclkload31 clknet_leaf_16_clk VGND VGND VPWR VPWR clkload31/Y sky130_fd_sc_hd__clkinvlp_4
Xclkload64 clknet_leaf_64_clk VGND VGND VPWR VPWR clkload64/Y sky130_fd_sc_hd__clkinv_2
X_3594_ net424 VGND VGND VPWR VPWR _0158_ sky130_fd_sc_hd__inv_2
Xclkload75 clknet_leaf_53_clk VGND VGND VPWR VPWR clkload75/Y sky130_fd_sc_hd__clkinv_2
X_2545_ lsu.current_load_addr\[16\] _1929_ VGND VGND VPWR VPWR _1946_ sky130_fd_sc_hd__or2_1
XTAP_TAPCELL_ROW_93_1254 VGND VPWR sky130_fd_sc_hd__tapvpwrvgnd_1
XFILLER_87_205 VPWR VGND VPWR VGND sky130_ef_sc_hd__decap_12
XPHY_EDGE_ROW_81_Left_188 VGND VGND VPWR VPWR sky130_fd_sc_hd__decap_3
X_2476_ _1895_ _1896_ net98 net265 VGND VGND VPWR VPWR _1897_ sky130_fd_sc_hd__a2bb2o_1
X_4215_ clknet_leaf_70_clk _0272_ VGND VGND VPWR VPWR lsu.store_fifo.queue\[5\]\[3\]
+ sky130_fd_sc_hd__dfxtp_1
X_4146_ clknet_leaf_1_clk _0203_ VGND VGND VPWR VPWR lsu.load_fifo.queue\[11\]\[6\]
+ sky130_fd_sc_hd__dfxtp_1
XFILLER_95_293 VPWR VGND VPWR VGND sky130_ef_sc_hd__decap_12
XFILLER_28_338 VGND VGND VPWR VPWR sky130_fd_sc_hd__fill_2
XFILLER_55_113 VGND VGND VPWR VPWR sky130_fd_sc_hd__fill_1
XFILLER_83_444 VGND VGND VPWR VPWR sky130_fd_sc_hd__decap_4
X_4077_ net270 _1510_ VGND VGND VPWR VPWR _1511_ sky130_fd_sc_hd__nor2_1
X_3028_ net1161 net312 net212 VGND VGND VPWR VPWR _0534_ sky130_fd_sc_hd__mux2_1
XTAP_TAPCELL_ROW_26_517 VGND VPWR sky130_fd_sc_hd__tapvpwrvgnd_1
XTAP_TAPCELL_ROW_54_826 VGND VPWR sky130_fd_sc_hd__tapvpwrvgnd_1
XPHY_EDGE_ROW_90_Left_197 VGND VGND VPWR VPWR sky130_fd_sc_hd__decap_3
XFILLER_34_26 VGND VGND VPWR VPWR sky130_fd_sc_hd__fill_2
XFILLER_36_382 VGND VGND VPWR VPWR sky130_fd_sc_hd__fill_1
XFILLER_24_566 VGND VGND VPWR VPWR sky130_fd_sc_hd__fill_1
XTAP_TAPCELL_ROW_102_1350 VGND VPWR sky130_fd_sc_hd__tapvpwrvgnd_1
X_4979_ clknet_leaf_32_clk _1034_ VGND VGND VPWR VPWR lsu.load_fifo.queue\[14\]\[0\]
+ sky130_fd_sc_hd__dfxtp_1
Xclkload3 clknet_3_4__leaf_clk VGND VGND VPWR VPWR clkload3/Y sky130_fd_sc_hd__inv_6
Xfanout240 _1723_ VGND VGND VPWR VPWR net240 sky130_fd_sc_hd__clkbuf_2
Xfanout262 net263 VGND VGND VPWR VPWR net262 sky130_fd_sc_hd__buf_2
Xfanout251 _2054_ VGND VGND VPWR VPWR net251 sky130_fd_sc_hd__buf_2
XFILLER_19_305 VGND VGND VPWR VPWR sky130_fd_sc_hd__fill_1
Xfanout273 acc.data_out\[9\] VGND VGND VPWR VPWR net273 sky130_fd_sc_hd__dlymetal6s2s_1
XFILLER_74_433 VPWR VGND VPWR VGND sky130_ef_sc_hd__decap_12
XTAP_TAPCELL_ROW_6_297 VGND VPWR sky130_fd_sc_hd__tapvpwrvgnd_1
Xfanout284 acc.data_out\[3\] VGND VGND VPWR VPWR net284 sky130_fd_sc_hd__clkbuf_2
Xfanout295 lsu.load_fifo.data_in\[30\] VGND VGND VPWR VPWR net295 sky130_fd_sc_hd__dlymetal6s2s_1
XFILLER_74_477 VPWR VGND VPWR VGND sky130_ef_sc_hd__decap_12
XFILLER_62_628 VGND VGND VPWR VPWR sky130_fd_sc_hd__fill_2
XFILLER_24_81 VGND VGND VPWR VPWR sky130_fd_sc_hd__decap_3
X_2330_ net363 _1253_ _1255_ lsu.load_fifo.w_ptr\[1\] lsu.load_fifo.w_ptr\[0\] VGND
+ VGND VPWR VPWR _1770_ sky130_fd_sc_hd__o2111ai_1
XFILLER_97_569 VGND VGND VPWR VPWR sky130_fd_sc_hd__fill_1
XFILLER_97_536 VGND VGND VPWR VPWR sky130_fd_sc_hd__fill_1
X_2261_ lsu.store_counter\[3\] lsu.store_counter\[2\] _1725_ VGND VGND VPWR VPWR _1726_
+ sky130_fd_sc_hd__and3_1
X_4000_ net401 lsu.store_fifo.w_ptr\[3\] VGND VGND VPWR VPWR _1440_ sky130_fd_sc_hd__xor2_1
X_2192_ net1302 _1680_ _1678_ VGND VGND VPWR VPWR _0926_ sky130_fd_sc_hd__o21ba_1
XFILLER_77_271 VGND VGND VPWR VPWR sky130_fd_sc_hd__decap_8
XFILLER_37_113 VGND VGND VPWR VPWR sky130_fd_sc_hd__decap_4
XFILLER_80_403 VGND VGND VPWR VPWR sky130_fd_sc_hd__fill_1
XFILLER_52_105 VGND VGND VPWR VPWR sky130_fd_sc_hd__fill_1
X_4902_ clknet_leaf_23_clk _0957_ VGND VGND VPWR VPWR lsu.load_fifo.queue\[12\]\[29\]
+ sky130_fd_sc_hd__dfxtp_1
X_4833_ clknet_leaf_41_clk _0890_ _0083_ VGND VGND VPWR VPWR lsu.store_counter\[10\]
+ sky130_fd_sc_hd__dfrtp_1
X_4764_ clknet_leaf_63_clk net1197 VGND VGND VPWR VPWR net128 sky130_fd_sc_hd__dfxtp_1
XTAP_TAPCELL_ROW_31_575 VGND VPWR sky130_fd_sc_hd__tapvpwrvgnd_1
X_3715_ _1193_ _1194_ VGND VGND VPWR VPWR _1197_ sky130_fd_sc_hd__xor2_1
X_4695_ clknet_leaf_74_clk _0752_ _0041_ VGND VGND VPWR VPWR lsu.load_fifo.r_ptr\[3\]
+ sky130_fd_sc_hd__dfrtp_2
X_3646_ acc.byte1\[7\] acc.byte0\[7\] VGND VGND VPWR VPWR _1128_ sky130_fd_sc_hd__or2_1
X_3577_ net425 VGND VGND VPWR VPWR _0141_ sky130_fd_sc_hd__inv_2
X_2528_ net166 net480 _1932_ net262 net243 VGND VGND VPWR VPWR _1934_ sky130_fd_sc_hd__o221a_1
XFILLER_88_525 VGND VGND VPWR VPWR sky130_fd_sc_hd__decap_6
X_2459_ net82 _1850_ net269 VGND VGND VPWR VPWR _1885_ sky130_fd_sc_hd__mux2_1
Xhold37 lsu.store_fifo.queue\[2\]\[0\] VGND VGND VPWR VPWR net505 sky130_fd_sc_hd__dlygate4sd3_1
Xhold59 lsu.store_fifo.queue\[10\]\[2\] VGND VGND VPWR VPWR net527 sky130_fd_sc_hd__dlygate4sd3_1
Xhold48 lsu.store_fifo.queue\[10\]\[6\] VGND VGND VPWR VPWR net516 sky130_fd_sc_hd__dlygate4sd3_1
XTAP_TAPCELL_ROW_3_267 VGND VPWR sky130_fd_sc_hd__tapvpwrvgnd_1
X_4129_ clknet_leaf_65_clk _0186_ VGND VGND VPWR VPWR lsu.store_fifo.queue\[11\]\[9\]
+ sky130_fd_sc_hd__dfxtp_1
XTAP_TAPCELL_ROW_67_962 VGND VPWR sky130_fd_sc_hd__tapvpwrvgnd_1
XFILLER_28_168 VGND VGND VPWR VPWR sky130_fd_sc_hd__decap_4
XTAP_TAPCELL_ROW_39_664 VGND VPWR sky130_fd_sc_hd__tapvpwrvgnd_1
XFILLER_101_42 VPWR VGND VPWR VGND sky130_ef_sc_hd__decap_12
XFILLER_12_525 VGND VGND VPWR VPWR sky130_fd_sc_hd__decap_6
XFILLER_12_569 VPWR VGND VPWR VGND sky130_ef_sc_hd__decap_12
XFILLER_3_223 VGND VGND VPWR VPWR sky130_fd_sc_hd__fill_1
XFILLER_105_195 VGND VGND VPWR VPWR sky130_fd_sc_hd__fill_1
XFILLER_87_580 VGND VGND VPWR VPWR sky130_fd_sc_hd__decap_8
XFILLER_19_113 VGND VGND VPWR VPWR sky130_fd_sc_hd__decap_4
XFILLER_30_377 VGND VGND VPWR VPWR sky130_fd_sc_hd__fill_1
X_3500_ net444 VGND VGND VPWR VPWR _0064_ sky130_fd_sc_hd__inv_2
X_4480_ clknet_leaf_32_clk _0537_ VGND VGND VPWR VPWR lsu.load_fifo.queue\[3\]\[24\]
+ sky130_fd_sc_hd__dfxtp_1
XFILLER_7_573 VPWR VGND VPWR VGND sky130_ef_sc_hd__decap_12
Xhold518 lsu.load_fifo.queue\[5\]\[18\] VGND VGND VPWR VPWR net986 sky130_fd_sc_hd__dlygate4sd3_1
Xhold507 lsu.load_fifo.queue\[6\]\[5\] VGND VGND VPWR VPWR net975 sky130_fd_sc_hd__dlygate4sd3_1
XTAP_TAPCELL_ROW_77_1079 VGND VPWR sky130_fd_sc_hd__tapvpwrvgnd_1
Xhold529 lsu.load_fifo.queue\[9\]\[2\] VGND VGND VPWR VPWR net997 sky130_fd_sc_hd__dlygate4sd3_1
X_3431_ net620 net285 _2059_ VGND VGND VPWR VPWR _1089_ sky130_fd_sc_hd__mux2_1
XTAP_TAPCELL_ROW_90_1224 VGND VPWR sky130_fd_sc_hd__tapvpwrvgnd_1
X_3362_ net333 net939 net169 VGND VGND VPWR VPWR _0971_ sky130_fd_sc_hd__mux2_1
X_2313_ lsu.store_counter\[6\] _1721_ VGND VGND VPWR VPWR _1762_ sky130_fd_sc_hd__nor2_1
X_3293_ lsu.load_fifo.data_in\[8\] net77 net251 VGND VGND VPWR VPWR _0855_ sky130_fd_sc_hd__mux2_1
X_2244_ lsu.load_counter\[0\] net483 _1711_ VGND VGND VPWR VPWR _0905_ sky130_fd_sc_hd__o21ba_1
X_5032_ clknet_leaf_63_clk _1087_ VGND VGND VPWR VPWR lsu.store_fifo.queue\[12\]\[1\]
+ sky130_fd_sc_hd__dfxtp_1
X_2175_ lsu.loader_state\[1\] _1664_ VGND VGND VPWR VPWR _1665_ sky130_fd_sc_hd__nand2_2
XTAP_TAPCELL_ROW_0_215 VGND VPWR sky130_fd_sc_hd__tapvpwrvgnd_1
XTAP_TAPCELL_ROW_0_226 VGND VPWR sky130_fd_sc_hd__tapvpwrvgnd_1
XTAP_TAPCELL_ROW_88_1197 VGND VPWR sky130_fd_sc_hd__tapvpwrvgnd_1
XFILLER_25_138 VGND VGND VPWR VPWR sky130_fd_sc_hd__fill_2
XTAP_TAPCELL_ROW_36_623 VGND VPWR sky130_fd_sc_hd__tapvpwrvgnd_1
XTAP_TAPCELL_ROW_64_932 VGND VPWR sky130_fd_sc_hd__tapvpwrvgnd_1
XFILLER_15_39 VGND VGND VPWR VPWR sky130_fd_sc_hd__fill_1
XFILLER_33_193 VGND VGND VPWR VPWR sky130_fd_sc_hd__fill_1
X_4816_ clknet_leaf_19_clk _0873_ VGND VGND VPWR VPWR lsu.load_fifo.data_in\[26\]
+ sky130_fd_sc_hd__dfxtp_1
X_4747_ clknet_leaf_47_clk _0804_ _0061_ VGND VGND VPWR VPWR lsu.current_store_addr\[15\]
+ sky130_fd_sc_hd__dfrtp_1
X_4678_ clknet_leaf_38_clk _0735_ _0024_ VGND VGND VPWR VPWR lsu.current_load_addr\[8\]
+ sky130_fd_sc_hd__dfrtp_4
X_3629_ lsu.current_load_addr\[19\] VGND VGND VPWR VPWR _1112_ sky130_fd_sc_hd__inv_2
XTAP_TAPCELL_ROW_8_315 VGND VPWR sky130_fd_sc_hd__tapvpwrvgnd_1
XFILLER_103_611 VGND VGND VPWR VPWR sky130_fd_sc_hd__decap_4
XFILLER_88_333 VPWR VGND VPWR VGND sky130_ef_sc_hd__decap_12
XFILLER_0_237 VGND VGND VPWR VPWR sky130_fd_sc_hd__decap_8
XFILLER_102_154 VGND VGND VPWR VPWR sky130_fd_sc_hd__fill_1
XFILLER_88_377 VPWR VGND VPWR VGND sky130_ef_sc_hd__decap_12
XFILLER_76_528 VGND VGND VPWR VPWR sky130_fd_sc_hd__fill_1
XFILLER_16_105 VGND VGND VPWR VPWR sky130_fd_sc_hd__decap_8
XFILLER_17_617 VPWR VGND VPWR VGND sky130_ef_sc_hd__decap_12
XFILLER_56_57 VGND VGND VPWR VPWR sky130_fd_sc_hd__decap_6
XFILLER_71_222 VGND VGND VPWR VPWR sky130_fd_sc_hd__fill_2
XFILLER_71_211 VGND VGND VPWR VPWR sky130_fd_sc_hd__fill_2
XFILLER_44_436 VGND VGND VPWR VPWR sky130_fd_sc_hd__decap_8
XFILLER_8_326 VPWR VGND VPWR VGND sky130_ef_sc_hd__decap_12
XFILLER_4_587 VGND VGND VPWR VPWR sky130_fd_sc_hd__fill_1
XFILLER_75_561 VGND VGND VPWR VPWR sky130_fd_sc_hd__decap_3
XFILLER_62_233 VGND VGND VPWR VPWR sky130_fd_sc_hd__fill_2
X_3980_ _1421_ _1423_ _1420_ _1422_ net356 net360 VGND VGND VPWR VPWR _1424_ sky130_fd_sc_hd__mux4_1
XTAP_TAPCELL_ROW_61_902 VGND VPWR sky130_fd_sc_hd__tapvpwrvgnd_1
XFILLER_50_439 VGND VGND VPWR VPWR sky130_fd_sc_hd__decap_6
X_2931_ net906 net303 net220 VGND VGND VPWR VPWR _0443_ sky130_fd_sc_hd__mux2_1
XFILLER_62_299 VGND VGND VPWR VPWR sky130_fd_sc_hd__decap_8
XFILLER_43_491 VGND VGND VPWR VPWR sky130_fd_sc_hd__decap_3
Xclkbuf_0_clk clk VGND VGND VPWR VPWR clknet_0_clk sky130_fd_sc_hd__clkbuf_16
XFILLER_87_3 VPWR VGND VPWR VGND sky130_ef_sc_hd__decap_12
X_4601_ clknet_leaf_69_clk _0658_ VGND VGND VPWR VPWR lsu.load_fifo.queue\[8\]\[17\]
+ sky130_fd_sc_hd__dfxtp_1
X_2862_ net973 net311 net223 VGND VGND VPWR VPWR _0373_ sky130_fd_sc_hd__mux2_1
XTAP_TAPCELL_ROW_13_372 VGND VPWR sky130_fd_sc_hd__tapvpwrvgnd_1
X_2793_ net823 net272 _2031_ VGND VGND VPWR VPWR _0308_ sky130_fd_sc_hd__mux2_1
XFILLER_30_174 VGND VGND VPWR VPWR sky130_fd_sc_hd__decap_6
XTAP_TAPCELL_ROW_41_681 VGND VPWR sky130_fd_sc_hd__tapvpwrvgnd_1
X_4532_ clknet_leaf_17_clk _0589_ VGND VGND VPWR VPWR lsu.load_fifo.queue\[1\]\[12\]
+ sky130_fd_sc_hd__dfxtp_1
Xhold304 net125 VGND VGND VPWR VPWR net772 sky130_fd_sc_hd__dlygate4sd3_1
Xhold326 _0812_ VGND VGND VPWR VPWR net794 sky130_fd_sc_hd__dlygate4sd3_1
X_4463_ clknet_leaf_32_clk _0520_ VGND VGND VPWR VPWR lsu.load_fifo.queue\[3\]\[7\]
+ sky130_fd_sc_hd__dfxtp_1
Xhold315 lsu.load_fifo.queue\[4\]\[14\] VGND VGND VPWR VPWR net783 sky130_fd_sc_hd__dlygate4sd3_1
Xhold337 net137 VGND VGND VPWR VPWR net805 sky130_fd_sc_hd__dlygate4sd3_1
Xhold359 lsu.load_fifo.queue\[14\]\[23\] VGND VGND VPWR VPWR net827 sky130_fd_sc_hd__dlygate4sd3_1
Xhold348 lsu.load_fifo.queue\[7\]\[25\] VGND VGND VPWR VPWR net816 sky130_fd_sc_hd__dlygate4sd3_1
X_3414_ net1094 net294 net200 VGND VGND VPWR VPWR _1064_ sky130_fd_sc_hd__mux2_1
X_4394_ clknet_leaf_20_clk _0451_ VGND VGND VPWR VPWR lsu.load_fifo.queue\[5\]\[2\]
+ sky130_fd_sc_hd__dfxtp_1
XPHY_EDGE_ROW_15_Right_15 VGND VGND VPWR VPWR sky130_fd_sc_hd__decap_3
X_3345_ net712 net301 net174 VGND VGND VPWR VPWR _0955_ sky130_fd_sc_hd__mux2_1
X_3276_ net1124 net286 _2053_ VGND VGND VPWR VPWR _0839_ sky130_fd_sc_hd__mux2_1
X_2227_ lsu.load_counter\[7\] _1701_ _1699_ VGND VGND VPWR VPWR _0912_ sky130_fd_sc_hd__o21ba_1
X_5015_ clknet_leaf_61_clk _1070_ VGND VGND VPWR VPWR lsu.store_fifo.queue\[13\]\[4\]
+ sky130_fd_sc_hd__dfxtp_1
XFILLER_85_369 VPWR VGND VPWR VGND sky130_ef_sc_hd__decap_12
X_2158_ lsu.load_counter\[15\] _1586_ _1646_ _1647_ VGND VGND VPWR VPWR _1648_ sky130_fd_sc_hd__o211a_1
XFILLER_26_414 VGND VGND VPWR VPWR sky130_fd_sc_hd__decap_6
XTAP_TAPCELL_ROW_49_770 VGND VPWR sky130_fd_sc_hd__tapvpwrvgnd_1
X_2089_ lsu.load_counter\[16\] _1576_ _1578_ lsu.load_counter\[17\] VGND VGND VPWR
+ VPWR _1579_ sky130_fd_sc_hd__o22ai_2
XFILLER_81_553 VGND VGND VPWR VPWR sky130_fd_sc_hd__decap_3
XPHY_EDGE_ROW_24_Right_24 VGND VGND VPWR VPWR sky130_fd_sc_hd__decap_3
XPHY_EDGE_ROW_33_Right_33 VGND VGND VPWR VPWR sky130_fd_sc_hd__decap_3
XFILLER_88_141 VGND VGND VPWR VPWR sky130_fd_sc_hd__decap_6
XFILLER_72_531 VGND VGND VPWR VPWR sky130_fd_sc_hd__fill_1
XPHY_EDGE_ROW_42_Right_42 VGND VGND VPWR VPWR sky130_fd_sc_hd__decap_3
XFILLER_72_542 VPWR VGND VPWR VGND sky130_ef_sc_hd__decap_12
XFILLER_17_447 VGND VGND VPWR VPWR sky130_fd_sc_hd__fill_1
XFILLER_72_575 VGND VGND VPWR VPWR sky130_fd_sc_hd__decap_3
XFILLER_16_60 VGND VGND VPWR VPWR sky130_fd_sc_hd__fill_1
XFILLER_16_93 VPWR VGND VPWR VGND sky130_ef_sc_hd__decap_12
XFILLER_25_491 VGND VGND VPWR VPWR sky130_fd_sc_hd__fill_1
XFILLER_12_141 VPWR VGND VPWR VGND sky130_ef_sc_hd__decap_12
XFILLER_8_101 VGND VGND VPWR VPWR sky130_fd_sc_hd__decap_4
Xlsu_wrapper_456 VGND VGND VPWR VPWR lsu_wrapper_456/HI store_data[19] sky130_fd_sc_hd__conb_1
XFILLER_12_174 VGND VGND VPWR VPWR sky130_fd_sc_hd__decap_4
XFILLER_8_145 VGND VGND VPWR VPWR sky130_fd_sc_hd__fill_1
XTAP_TAPCELL_ROW_10_342 VGND VPWR sky130_fd_sc_hd__tapvpwrvgnd_1
XFILLER_8_178 VGND VGND VPWR VPWR sky130_fd_sc_hd__fill_2
Xlsu_wrapper_467 VGND VGND VPWR VPWR lsu_wrapper_467/HI store_data[30] sky130_fd_sc_hd__conb_1
XPHY_EDGE_ROW_51_Right_51 VGND VGND VPWR VPWR sky130_fd_sc_hd__decap_3
XTAP_TAPCELL_ROW_74_1049 VGND VPWR sky130_fd_sc_hd__tapvpwrvgnd_1
X_3130_ net711 net306 net184 VGND VGND VPWR VPWR _0633_ sky130_fd_sc_hd__mux2_1
XFILLER_94_133 VGND VGND VPWR VPWR sky130_fd_sc_hd__decap_6
X_3061_ net836 net312 net208 VGND VGND VPWR VPWR _0566_ sky130_fd_sc_hd__mux2_1
XPHY_EDGE_ROW_60_Right_60 VGND VGND VPWR VPWR sky130_fd_sc_hd__decap_3
XFILLER_94_188 VGND VGND VPWR VPWR sky130_fd_sc_hd__decap_8
XFILLER_48_583 VGND VGND VPWR VPWR sky130_fd_sc_hd__fill_2
XTAP_TAPCELL_ROW_18_431 VGND VPWR sky130_fd_sc_hd__tapvpwrvgnd_1
XFILLER_35_233 VGND VGND VPWR VPWR sky130_fd_sc_hd__decap_3
XFILLER_35_244 VGND VGND VPWR VPWR sky130_fd_sc_hd__decap_3
XTAP_TAPCELL_ROW_46_740 VGND VPWR sky130_fd_sc_hd__tapvpwrvgnd_1
XFILLER_63_553 VGND VGND VPWR VPWR sky130_fd_sc_hd__decap_6
XTAP_TAPCELL_ROW_85_1167 VGND VPWR sky130_fd_sc_hd__tapvpwrvgnd_1
X_3963_ lsu.load_fifo.queue\[0\]\[5\] lsu.load_fifo.queue\[1\]\[5\] lsu.load_fifo.queue\[2\]\[5\]
+ lsu.load_fifo.queue\[3\]\[5\] net391 net374 VGND VGND VPWR VPWR _1409_ sky130_fd_sc_hd__mux4_1
X_2914_ net1054 net336 net218 VGND VGND VPWR VPWR _0426_ sky130_fd_sc_hd__mux2_1
X_3894_ lsu.load_fifo.queue\[0\]\[15\] lsu.load_fifo.queue\[1\]\[15\] lsu.load_fifo.queue\[2\]\[15\]
+ lsu.load_fifo.queue\[3\]\[15\] net395 net378 VGND VGND VPWR VPWR _1350_ sky130_fd_sc_hd__mux4_1
X_2845_ net734 net345 net222 VGND VGND VPWR VPWR _0356_ sky130_fd_sc_hd__mux2_1
XFILLER_12_29 VGND VGND VPWR VPWR sky130_fd_sc_hd__decap_4
X_4515_ clknet_leaf_82_clk _0572_ VGND VGND VPWR VPWR lsu.load_fifo.queue\[2\]\[27\]
+ sky130_fd_sc_hd__dfxtp_1
X_2776_ net284 net1175 _2030_ VGND VGND VPWR VPWR _0292_ sky130_fd_sc_hd__mux2_1
Xhold101 lsu.load_fifo.queue\[2\]\[12\] VGND VGND VPWR VPWR net569 sky130_fd_sc_hd__dlygate4sd3_1
XPHY_EDGE_ROW_103_Right_103 VGND VGND VPWR VPWR sky130_fd_sc_hd__decap_3
XTAP_TAPCELL_ROW_96_1285 VGND VPWR sky130_fd_sc_hd__tapvpwrvgnd_1
Xhold112 lsu.load_fifo.queue\[6\]\[10\] VGND VGND VPWR VPWR net580 sky130_fd_sc_hd__dlygate4sd3_1
Xhold134 lsu.load_fifo.queue\[5\]\[12\] VGND VGND VPWR VPWR net602 sky130_fd_sc_hd__dlygate4sd3_1
Xhold123 lsu.load_fifo.queue\[15\]\[2\] VGND VGND VPWR VPWR net591 sky130_fd_sc_hd__dlygate4sd3_1
X_4446_ clknet_leaf_72_clk _0503_ VGND VGND VPWR VPWR lsu.load_fifo.queue\[4\]\[22\]
+ sky130_fd_sc_hd__dfxtp_1
Xhold156 lsu.store_fifo.queue\[0\]\[5\] VGND VGND VPWR VPWR net624 sky130_fd_sc_hd__dlygate4sd3_1
Xhold167 lsu.load_fifo.queue\[0\]\[5\] VGND VGND VPWR VPWR net635 sky130_fd_sc_hd__dlygate4sd3_1
Xhold145 lsu.load_fifo.queue\[14\]\[4\] VGND VGND VPWR VPWR net613 sky130_fd_sc_hd__dlygate4sd3_1
XFILLER_104_249 VGND VGND VPWR VPWR sky130_fd_sc_hd__decap_3
X_4377_ clknet_leaf_80_clk _0434_ VGND VGND VPWR VPWR lsu.load_fifo.queue\[6\]\[17\]
+ sky130_fd_sc_hd__dfxtp_1
Xhold178 lsu.store_fifo.queue\[14\]\[7\] VGND VGND VPWR VPWR net646 sky130_fd_sc_hd__dlygate4sd3_1
Xhold189 lsu.load_fifo.queue\[11\]\[5\] VGND VGND VPWR VPWR net657 sky130_fd_sc_hd__dlygate4sd3_1
X_3328_ net572 net334 net175 VGND VGND VPWR VPWR _0938_ sky130_fd_sc_hd__mux2_1
XFILLER_85_111 VGND VGND VPWR VPWR sky130_fd_sc_hd__fill_1
XFILLER_100_477 VGND VGND VPWR VPWR sky130_fd_sc_hd__fill_1
XFILLER_100_455 VGND VGND VPWR VPWR sky130_fd_sc_hd__fill_2
XFILLER_37_37 VGND VGND VPWR VPWR sky130_fd_sc_hd__fill_1
X_3259_ lsu.current_store_addr\[8\] net703 net257 VGND VGND VPWR VPWR _0819_ sky130_fd_sc_hd__mux2_1
XFILLER_26_266 VGND VGND VPWR VPWR sky130_fd_sc_hd__fill_1
XTAP_TAPCELL_ROW_105_1381 VGND VPWR sky130_fd_sc_hd__tapvpwrvgnd_1
XFILLER_10_601 VPWR VGND VPWR VGND sky130_ef_sc_hd__decap_12
XTAP_TAPCELL_ROW_24_489 VGND VPWR sky130_fd_sc_hd__tapvpwrvgnd_1
XTAP_TAPCELL_ROW_52_798 VGND VPWR sky130_fd_sc_hd__tapvpwrvgnd_1
Xhold690 lsu.store_fifo.queue\[9\]\[7\] VGND VGND VPWR VPWR net1158 sky130_fd_sc_hd__dlygate4sd3_1
XFILLER_94_65 VPWR VGND VPWR VGND sky130_ef_sc_hd__decap_12
XFILLER_91_125 VPWR VGND VPWR VGND sky130_ef_sc_hd__decap_12
XFILLER_64_339 VPWR VGND VPWR VGND sky130_ef_sc_hd__decap_12
XFILLER_91_169 VPWR VGND VPWR VGND sky130_ef_sc_hd__decap_12
XFILLER_91_158 VGND VGND VPWR VPWR sky130_fd_sc_hd__decap_8
XFILLER_17_233 VGND VGND VPWR VPWR sky130_fd_sc_hd__decap_8
XFILLER_17_222 VGND VGND VPWR VPWR sky130_fd_sc_hd__fill_2
XFILLER_45_575 VPWR VGND VPWR VGND sky130_ef_sc_hd__decap_12
XFILLER_13_461 VPWR VGND VPWR VGND sky130_ef_sc_hd__decap_12
XFILLER_20_409 VGND VGND VPWR VPWR sky130_fd_sc_hd__decap_3
X_2630_ net405 _1440_ _1441_ VGND VGND VPWR VPWR _2006_ sky130_fd_sc_hd__o21ai_1
X_2561_ lsu.current_load_addr\[12\] _1926_ VGND VGND VPWR VPWR _1958_ sky130_fd_sc_hd__or2_1
XFILLER_99_225 VGND VGND VPWR VPWR sky130_fd_sc_hd__fill_1
XFILLER_99_214 VGND VGND VPWR VPWR sky130_fd_sc_hd__fill_1
X_2492_ lsu.current_store_addr\[0\] net267 net241 VGND VGND VPWR VPWR _1908_ sky130_fd_sc_hd__o21a_1
X_4300_ clknet_leaf_1_clk _0357_ VGND VGND VPWR VPWR lsu.load_fifo.queue\[10\]\[6\]
+ sky130_fd_sc_hd__dfxtp_1
XFILLER_87_409 VPWR VGND VPWR VGND sky130_ef_sc_hd__decap_12
XFILLER_4_41 VPWR VGND VPWR VGND sky130_ef_sc_hd__decap_12
X_4231_ clknet_leaf_70_clk _0288_ VGND VGND VPWR VPWR lsu.store_fifo.queue\[4\]\[9\]
+ sky130_fd_sc_hd__dfxtp_1
XFILLER_4_85 VPWR VGND VPWR VGND sky130_ef_sc_hd__decap_12
X_4162_ clknet_leaf_72_clk _0219_ VGND VGND VPWR VPWR lsu.load_fifo.queue\[11\]\[22\]
+ sky130_fd_sc_hd__dfxtp_1
X_3113_ net792 net341 net184 VGND VGND VPWR VPWR _0616_ sky130_fd_sc_hd__mux2_1
X_4093_ net405 _1519_ _1521_ _1524_ _1525_ VGND VGND VPWR VPWR _1526_ sky130_fd_sc_hd__o32a_1
X_3044_ net869 net347 net208 VGND VGND VPWR VPWR _0549_ sky130_fd_sc_hd__mux2_1
XFILLER_70_309 VGND VGND VPWR VPWR sky130_fd_sc_hd__fill_1
XFILLER_36_531 VGND VGND VPWR VPWR sky130_fd_sc_hd__fill_1
XFILLER_36_586 VGND VGND VPWR VPWR sky130_fd_sc_hd__fill_2
X_4995_ clknet_leaf_31_clk _1050_ VGND VGND VPWR VPWR lsu.load_fifo.queue\[14\]\[16\]
+ sky130_fd_sc_hd__dfxtp_1
XFILLER_23_225 VGND VGND VPWR VPWR sky130_fd_sc_hd__decap_3
XFILLER_51_534 VGND VGND VPWR VPWR sky130_fd_sc_hd__fill_1
X_3946_ lsu.load_fifo.queue\[8\]\[7\] lsu.load_fifo.queue\[9\]\[7\] lsu.load_fifo.queue\[10\]\[7\]
+ lsu.load_fifo.queue\[11\]\[7\] net396 net379 VGND VGND VPWR VPWR _1394_ sky130_fd_sc_hd__mux4_1
XTAP_TAPCELL_ROW_98_1303 VGND VPWR sky130_fd_sc_hd__tapvpwrvgnd_1
XTAP_TAPCELL_ROW_21_459 VGND VPWR sky130_fd_sc_hd__tapvpwrvgnd_1
X_3877_ net1287 _1335_ net253 VGND VGND VPWR VPWR _1020_ sky130_fd_sc_hd__mux2_1
X_2828_ net311 net1117 net227 VGND VGND VPWR VPWR _0341_ sky130_fd_sc_hd__mux2_1
X_2759_ net272 net1178 _2027_ VGND VGND VPWR VPWR _0278_ sky130_fd_sc_hd__mux2_1
X_4429_ clknet_leaf_4_clk _0486_ VGND VGND VPWR VPWR lsu.load_fifo.queue\[4\]\[5\]
+ sky130_fd_sc_hd__dfxtp_1
Xfanout411 net413 VGND VGND VPWR VPWR net411 sky130_fd_sc_hd__buf_4
Xfanout400 net402 VGND VGND VPWR VPWR net400 sky130_fd_sc_hd__buf_2
Xfanout422 net423 VGND VGND VPWR VPWR net422 sky130_fd_sc_hd__buf_4
Xfanout444 net445 VGND VGND VPWR VPWR net444 sky130_fd_sc_hd__buf_2
Xfanout433 net434 VGND VGND VPWR VPWR net433 sky130_fd_sc_hd__buf_2
XFILLER_86_475 VGND VGND VPWR VPWR sky130_fd_sc_hd__fill_1
XPHY_EDGE_ROW_100_Left_207 VGND VGND VPWR VPWR sky130_fd_sc_hd__decap_3
XTAP_TAPCELL_ROW_29_548 VGND VPWR sky130_fd_sc_hd__tapvpwrvgnd_1
XTAP_TAPCELL_ROW_57_857 VGND VPWR sky130_fd_sc_hd__tapvpwrvgnd_1
XFILLER_73_169 VGND VGND VPWR VPWR sky130_fd_sc_hd__fill_2
XFILLER_27_597 VGND VGND VPWR VPWR sky130_fd_sc_hd__decap_8
XFILLER_10_475 VGND VGND VPWR VPWR sky130_fd_sc_hd__fill_1
XFILLER_6_457 VPWR VGND VPWR VGND sky130_ef_sc_hd__decap_12
XTAP_TAPCELL_ROW_71_1008 VGND VPWR sky130_fd_sc_hd__tapvpwrvgnd_1
XFILLER_77_464 VPWR VGND VPWR VGND sky130_ef_sc_hd__decap_12
XFILLER_64_136 VGND VGND VPWR VPWR sky130_fd_sc_hd__decap_4
XFILLER_18_586 VGND VGND VPWR VPWR sky130_fd_sc_hd__fill_2
XTAP_TAPCELL_ROW_82_1137 VGND VPWR sky130_fd_sc_hd__tapvpwrvgnd_1
X_3800_ _1267_ _1269_ _1266_ _1268_ net358 net364 VGND VGND VPWR VPWR _1270_ sky130_fd_sc_hd__mux4_1
X_4780_ clknet_leaf_53_clk _0837_ VGND VGND VPWR VPWR lsu.store_fifo.queue\[0\]\[0\]
+ sky130_fd_sc_hd__dfxtp_1
X_3731_ _1208_ _1210_ VGND VGND VPWR VPWR _1213_ sky130_fd_sc_hd__xor2_1
Xclkload10 clknet_leaf_3_clk VGND VGND VPWR VPWR clkload10/Y sky130_fd_sc_hd__clkinv_2
X_3662_ acc.byte1\[0\] acc.byte0\[0\] VGND VGND VPWR VPWR _1144_ sky130_fd_sc_hd__nand2_1
Xclkload21 clknet_leaf_74_clk VGND VGND VPWR VPWR clkload21/Y sky130_fd_sc_hd__inv_12
X_2613_ net414 _1447_ net410 VGND VGND VPWR VPWR _1995_ sky130_fd_sc_hd__a21oi_1
Xclkload32 clknet_leaf_17_clk VGND VGND VPWR VPWR clkload32/X sky130_fd_sc_hd__clkbuf_4
Xclkload43 clknet_leaf_13_clk VGND VGND VPWR VPWR clkload43/Y sky130_fd_sc_hd__inv_6
X_3593_ net425 VGND VGND VPWR VPWR _0157_ sky130_fd_sc_hd__inv_2
X_2544_ lsu.current_load_addr\[17\] _1945_ net476 VGND VGND VPWR VPWR _0744_ sky130_fd_sc_hd__mux2_4
Xclkload54 clknet_leaf_69_clk VGND VGND VPWR VPWR clkload54/Y sky130_fd_sc_hd__clkinv_8
Xclkload65 clknet_leaf_65_clk VGND VGND VPWR VPWR clkload65/X sky130_fd_sc_hd__clkbuf_8
Xclkload76 clknet_leaf_54_clk VGND VGND VPWR VPWR clkload76/Y sky130_fd_sc_hd__bufinv_16
XTAP_TAPCELL_ROW_93_1255 VGND VPWR sky130_fd_sc_hd__tapvpwrvgnd_1
XFILLER_87_217 VGND VGND VPWR VPWR sky130_fd_sc_hd__decap_6
X_2475_ lsu.current_store_addr\[6\] _1845_ VGND VGND VPWR VPWR _1896_ sky130_fd_sc_hd__nor2_1
X_4214_ clknet_leaf_56_clk _0271_ VGND VGND VPWR VPWR lsu.store_fifo.queue\[5\]\[2\]
+ sky130_fd_sc_hd__dfxtp_1
XFILLER_68_464 VGND VGND VPWR VPWR sky130_fd_sc_hd__fill_2
X_4145_ clknet_leaf_5_clk _0202_ VGND VGND VPWR VPWR lsu.load_fifo.queue\[11\]\[5\]
+ sky130_fd_sc_hd__dfxtp_1
XFILLER_95_261 VPWR VGND VPWR VGND sky130_ef_sc_hd__decap_12
X_4076_ lsu.store_fifo.queue\[8\]\[3\] lsu.store_fifo.queue\[9\]\[3\] lsu.store_fifo.queue\[10\]\[3\]
+ lsu.store_fifo.queue\[11\]\[3\] net412 net407 VGND VGND VPWR VPWR _1510_ sky130_fd_sc_hd__mux4_1
X_3027_ net828 net314 net210 VGND VGND VPWR VPWR _0533_ sky130_fd_sc_hd__mux2_1
XTAP_TAPCELL_ROW_26_518 VGND VPWR sky130_fd_sc_hd__tapvpwrvgnd_1
XTAP_TAPCELL_ROW_54_827 VGND VPWR sky130_fd_sc_hd__tapvpwrvgnd_1
XFILLER_51_320 VGND VGND VPWR VPWR sky130_fd_sc_hd__decap_4
XFILLER_63_191 VGND VGND VPWR VPWR sky130_fd_sc_hd__fill_1
XTAP_TAPCELL_ROW_102_1351 VGND VPWR sky130_fd_sc_hd__tapvpwrvgnd_1
XFILLER_11_206 VGND VGND VPWR VPWR sky130_fd_sc_hd__decap_4
XFILLER_24_589 VPWR VGND VPWR VGND sky130_ef_sc_hd__decap_12
X_4978_ clknet_leaf_75_clk _1033_ _0164_ VGND VGND VPWR VPWR acc.byte3\[7\] sky130_fd_sc_hd__dfrtp_1
X_3929_ lsu.load_fifo.queue\[8\]\[10\] lsu.load_fifo.queue\[9\]\[10\] lsu.load_fifo.queue\[10\]\[10\]
+ lsu.load_fifo.queue\[11\]\[10\] net393 net376 VGND VGND VPWR VPWR _1380_ sky130_fd_sc_hd__mux4_1
Xclkload4 clknet_3_5__leaf_clk VGND VGND VPWR VPWR clkload4/Y sky130_fd_sc_hd__inv_6
XFILLER_50_37 VGND VGND VPWR VPWR sky130_fd_sc_hd__decap_4
XFILLER_50_59 VGND VGND VPWR VPWR sky130_fd_sc_hd__fill_2
XFILLER_3_405 VPWR VGND VPWR VGND sky130_ef_sc_hd__decap_12
XFILLER_3_449 VPWR VGND VPWR VGND sky130_ef_sc_hd__decap_12
Xfanout241 net242 VGND VGND VPWR VPWR net241 sky130_fd_sc_hd__buf_2
Xfanout230 _2022_ VGND VGND VPWR VPWR net230 sky130_fd_sc_hd__buf_4
Xfanout263 _1548_ VGND VGND VPWR VPWR net263 sky130_fd_sc_hd__buf_2
Xfanout252 _1724_ VGND VGND VPWR VPWR net252 sky130_fd_sc_hd__clkbuf_4
Xfanout274 acc.data_out\[8\] VGND VGND VPWR VPWR net274 sky130_fd_sc_hd__clkbuf_2
Xfanout296 net297 VGND VGND VPWR VPWR net296 sky130_fd_sc_hd__clkbuf_2
XTAP_TAPCELL_ROW_6_298 VGND VPWR sky130_fd_sc_hd__tapvpwrvgnd_1
Xfanout285 acc.data_out\[3\] VGND VGND VPWR VPWR net285 sky130_fd_sc_hd__clkbuf_2
XFILLER_74_445 VPWR VGND VPWR VGND sky130_ef_sc_hd__decap_12
XFILLER_74_489 VPWR VGND VPWR VGND sky130_ef_sc_hd__decap_12
XFILLER_54_180 VPWR VGND VPWR VGND sky130_ef_sc_hd__decap_12
XFILLER_91_55 VGND VGND VPWR VPWR sky130_fd_sc_hd__fill_1
XFILLER_10_250 VGND VGND VPWR VPWR sky130_fd_sc_hd__fill_2
XFILLER_69_206 VGND VGND VPWR VPWR sky130_fd_sc_hd__fill_2
XFILLER_97_559 VGND VGND VPWR VPWR sky130_fd_sc_hd__fill_1
X_2260_ lsu.store_counter\[1\] lsu.store_counter\[0\] VGND VGND VPWR VPWR _1725_ sky130_fd_sc_hd__and2_1
XFILLER_34_6 VGND VGND VPWR VPWR sky130_fd_sc_hd__decap_3
X_2191_ net167 net164 _1676_ net244 lsu.load_counter\[20\] VGND VGND VPWR VPWR _1680_
+ sky130_fd_sc_hd__o2111a_1
XFILLER_92_253 VPWR VGND VPWR VGND sky130_ef_sc_hd__decap_12
XFILLER_37_169 VGND VGND VPWR VPWR sky130_fd_sc_hd__decap_6
XFILLER_52_139 VGND VGND VPWR VPWR sky130_fd_sc_hd__fill_1
X_4901_ clknet_leaf_16_clk _0956_ VGND VGND VPWR VPWR lsu.load_fifo.queue\[12\]\[28\]
+ sky130_fd_sc_hd__dfxtp_1
XFILLER_33_331 VGND VGND VPWR VPWR sky130_fd_sc_hd__decap_4
X_4832_ clknet_leaf_40_clk _0889_ _0082_ VGND VGND VPWR VPWR lsu.store_counter\[9\]
+ sky130_fd_sc_hd__dfrtp_1
X_4763_ clknet_leaf_47_clk _0820_ VGND VGND VPWR VPWR net148 sky130_fd_sc_hd__dfxtp_1
XFILLER_21_559 VGND VGND VPWR VPWR sky130_fd_sc_hd__fill_1
XTAP_TAPCELL_ROW_31_576 VGND VPWR sky130_fd_sc_hd__tapvpwrvgnd_1
X_3714_ _1190_ _1195_ VGND VGND VPWR VPWR _1196_ sky130_fd_sc_hd__nor2_1
X_4694_ clknet_leaf_74_clk _0751_ _0040_ VGND VGND VPWR VPWR lsu.load_fifo.r_ptr\[2\]
+ sky130_fd_sc_hd__dfrtp_1
XFILLER_20_29 VGND VGND VPWR VPWR sky130_fd_sc_hd__fill_1
X_3645_ acc.byte1\[7\] acc.byte0\[7\] VGND VGND VPWR VPWR _1127_ sky130_fd_sc_hd__and2_1
X_3576_ net425 VGND VGND VPWR VPWR _0140_ sky130_fd_sc_hd__inv_2
X_2527_ lsu.current_load_addr\[21\] net264 _1932_ _1919_ VGND VGND VPWR VPWR _1933_
+ sky130_fd_sc_hd__a31o_1
XFILLER_88_559 VGND VGND VPWR VPWR sky130_fd_sc_hd__fill_1
X_2458_ net238 _1883_ VGND VGND VPWR VPWR _1884_ sky130_fd_sc_hd__and2_1
XPHY_EDGE_ROW_89_Right_89 VGND VGND VPWR VPWR sky130_fd_sc_hd__decap_3
XFILLER_29_38 VGND VGND VPWR VPWR sky130_fd_sc_hd__fill_1
Xhold38 lsu.store_fifo.queue\[6\]\[8\] VGND VGND VPWR VPWR net506 sky130_fd_sc_hd__dlygate4sd3_1
X_2389_ _1784_ _1786_ VGND VGND VPWR VPWR _1828_ sky130_fd_sc_hd__and2b_1
Xhold49 lsu.load_fifo.queue\[0\]\[8\] VGND VGND VPWR VPWR net517 sky130_fd_sc_hd__dlygate4sd3_1
XTAP_TAPCELL_ROW_3_268 VGND VPWR sky130_fd_sc_hd__tapvpwrvgnd_1
XFILLER_28_136 VGND VGND VPWR VPWR sky130_fd_sc_hd__decap_4
X_4128_ clknet_leaf_60_clk _0185_ VGND VGND VPWR VPWR lsu.store_fifo.queue\[11\]\[8\]
+ sky130_fd_sc_hd__dfxtp_1
X_4059_ net400 _1492_ net403 VGND VGND VPWR VPWR _1495_ sky130_fd_sc_hd__o21ai_1
XTAP_TAPCELL_ROW_39_654 VGND VPWR sky130_fd_sc_hd__tapvpwrvgnd_1
XTAP_TAPCELL_ROW_67_963 VGND VPWR sky130_fd_sc_hd__tapvpwrvgnd_1
XFILLER_24_353 VGND VGND VPWR VPWR sky130_fd_sc_hd__fill_2
XFILLER_36_191 VGND VGND VPWR VPWR sky130_fd_sc_hd__decap_4
XFILLER_101_54 VGND VGND VPWR VPWR sky130_fd_sc_hd__fill_2
XPHY_EDGE_ROW_98_Right_98 VGND VGND VPWR VPWR sky130_fd_sc_hd__decap_3
XFILLER_24_397 VPWR VGND VPWR VGND sky130_ef_sc_hd__decap_12
XFILLER_79_548 VGND VGND VPWR VPWR sky130_fd_sc_hd__decap_6
XFILLER_74_242 VGND VGND VPWR VPWR sky130_fd_sc_hd__fill_1
XFILLER_34_139 VGND VGND VPWR VPWR sky130_fd_sc_hd__fill_1
XFILLER_35_70 VGND VGND VPWR VPWR sky130_fd_sc_hd__fill_1
XFILLER_30_345 VGND VGND VPWR VPWR sky130_fd_sc_hd__fill_1
XFILLER_7_541 VPWR VGND VPWR VGND sky130_ef_sc_hd__decap_12
XFILLER_7_585 VPWR VGND VPWR VGND sky130_ef_sc_hd__decap_12
Xhold508 lsu.load_fifo.queue\[6\]\[17\] VGND VGND VPWR VPWR net976 sky130_fd_sc_hd__dlygate4sd3_1
Xhold519 lsu.load_fifo.queue\[5\]\[10\] VGND VGND VPWR VPWR net987 sky130_fd_sc_hd__dlygate4sd3_1
X_3430_ net685 net287 _2059_ VGND VGND VPWR VPWR _1088_ sky130_fd_sc_hd__mux2_1
X_3361_ net334 net1121 net171 VGND VGND VPWR VPWR _0970_ sky130_fd_sc_hd__mux2_1
XTAP_TAPCELL_ROW_90_1225 VGND VPWR sky130_fd_sc_hd__tapvpwrvgnd_1
X_2312_ net266 _1727_ net239 VGND VGND VPWR VPWR _1761_ sky130_fd_sc_hd__o21ai_1
XFILLER_32_3 VGND VGND VPWR VPWR sky130_fd_sc_hd__fill_2
X_3292_ net1280 net76 net251 VGND VGND VPWR VPWR _0854_ sky130_fd_sc_hd__mux2_1
X_5031_ clknet_leaf_48_clk _1086_ VGND VGND VPWR VPWR lsu.store_fifo.queue\[12\]\[0\]
+ sky130_fd_sc_hd__dfxtp_1
XFILLER_97_378 VPWR VGND VPWR VGND sky130_ef_sc_hd__decap_12
X_2243_ lsu.load_counter\[1\] _1711_ _1709_ VGND VGND VPWR VPWR _0906_ sky130_fd_sc_hd__o21a_1
X_2174_ _1660_ _1654_ lsu.load_counter\[22\] _1570_ VGND VGND VPWR VPWR _1664_ sky130_fd_sc_hd__a31o_1
XTAP_TAPCELL_ROW_0_216 VGND VPWR sky130_fd_sc_hd__tapvpwrvgnd_1
XTAP_TAPCELL_ROW_0_227 VGND VPWR sky130_fd_sc_hd__tapvpwrvgnd_1
XFILLER_25_106 VGND VGND VPWR VPWR sky130_fd_sc_hd__decap_6
XFILLER_26_629 VGND VGND VPWR VPWR sky130_fd_sc_hd__fill_1
XFILLER_65_253 VGND VGND VPWR VPWR sky130_fd_sc_hd__fill_1
XFILLER_65_275 VGND VGND VPWR VPWR sky130_fd_sc_hd__decap_4
XTAP_TAPCELL_ROW_88_1198 VGND VPWR sky130_fd_sc_hd__tapvpwrvgnd_1
XTAP_TAPCELL_ROW_36_624 VGND VPWR sky130_fd_sc_hd__tapvpwrvgnd_1
XTAP_TAPCELL_ROW_64_933 VGND VPWR sky130_fd_sc_hd__tapvpwrvgnd_1
X_4815_ clknet_leaf_68_clk _0872_ VGND VGND VPWR VPWR lsu.load_fifo.data_in\[25\]
+ sky130_fd_sc_hd__dfxtp_1
XFILLER_21_389 VGND VGND VPWR VPWR sky130_fd_sc_hd__decap_3
X_4746_ clknet_leaf_48_clk _0803_ _0060_ VGND VGND VPWR VPWR lsu.current_store_addr\[14\]
+ sky130_fd_sc_hd__dfrtp_1
X_4677_ clknet_leaf_29_clk _0734_ _0023_ VGND VGND VPWR VPWR lsu.current_load_addr\[7\]
+ sky130_fd_sc_hd__dfrtp_4
X_3628_ net396 VGND VGND VPWR VPWR _1111_ sky130_fd_sc_hd__inv_2
XTAP_TAPCELL_ROW_8_316 VGND VPWR sky130_fd_sc_hd__tapvpwrvgnd_1
X_3559_ net432 VGND VGND VPWR VPWR _0123_ sky130_fd_sc_hd__inv_2
XFILLER_88_345 VPWR VGND VPWR VGND sky130_ef_sc_hd__decap_12
XFILLER_88_389 VPWR VGND VPWR VGND sky130_ef_sc_hd__decap_12
XFILLER_56_14 VGND VGND VPWR VPWR sky130_fd_sc_hd__decap_3
XFILLER_29_445 VGND VGND VPWR VPWR sky130_fd_sc_hd__decap_3
XFILLER_56_25 VGND VGND VPWR VPWR sky130_fd_sc_hd__decap_3
XFILLER_84_551 VGND VGND VPWR VPWR sky130_fd_sc_hd__decap_3
XFILLER_17_629 VGND VGND VPWR VPWR sky130_fd_sc_hd__fill_1
XFILLER_56_253 VGND VGND VPWR VPWR sky130_fd_sc_hd__decap_6
XFILLER_72_46 VGND VGND VPWR VPWR sky130_fd_sc_hd__fill_1
XFILLER_71_289 VGND VGND VPWR VPWR sky130_fd_sc_hd__fill_2
XFILLER_8_338 VGND VGND VPWR VPWR sky130_fd_sc_hd__decap_8
XFILLER_4_533 VPWR VGND VPWR VGND sky130_ef_sc_hd__decap_12
XFILLER_98_109 VPWR VGND VPWR VGND sky130_ef_sc_hd__decap_12
XFILLER_79_345 VGND VGND VPWR VPWR sky130_fd_sc_hd__fill_1
XTAP_TAPCELL_ROW_61_903 VGND VPWR sky130_fd_sc_hd__tapvpwrvgnd_1
XFILLER_90_587 VGND VGND VPWR VPWR sky130_fd_sc_hd__fill_1
X_2930_ net840 net305 net219 VGND VGND VPWR VPWR _0442_ sky130_fd_sc_hd__mux2_1
X_4600_ clknet_leaf_30_clk _0657_ VGND VGND VPWR VPWR lsu.load_fifo.queue\[8\]\[16\]
+ sky130_fd_sc_hd__dfxtp_1
X_2861_ net819 net313 net224 VGND VGND VPWR VPWR _0372_ sky130_fd_sc_hd__mux2_1
XTAP_TAPCELL_ROW_13_373 VGND VPWR sky130_fd_sc_hd__tapvpwrvgnd_1
XTAP_TAPCELL_ROW_41_682 VGND VPWR sky130_fd_sc_hd__tapvpwrvgnd_1
X_2792_ net1009 net274 _2031_ VGND VGND VPWR VPWR _0307_ sky130_fd_sc_hd__mux2_1
X_4531_ clknet_leaf_85_clk _0588_ VGND VGND VPWR VPWR lsu.load_fifo.queue\[1\]\[11\]
+ sky130_fd_sc_hd__dfxtp_1
Xhold305 _0775_ VGND VGND VPWR VPWR net773 sky130_fd_sc_hd__dlygate4sd3_1
Xhold316 lsu.load_fifo.queue\[12\]\[16\] VGND VGND VPWR VPWR net784 sky130_fd_sc_hd__dlygate4sd3_1
X_4462_ clknet_leaf_87_clk _0519_ VGND VGND VPWR VPWR lsu.load_fifo.queue\[3\]\[6\]
+ sky130_fd_sc_hd__dfxtp_1
X_3413_ net1183 net296 net200 VGND VGND VPWR VPWR _1063_ sky130_fd_sc_hd__mux2_1
Xhold349 net146 VGND VGND VPWR VPWR net817 sky130_fd_sc_hd__dlygate4sd3_1
Xhold338 lsu.load_fifo.queue\[11\]\[14\] VGND VGND VPWR VPWR net806 sky130_fd_sc_hd__dlygate4sd3_1
Xhold327 lsu.store_fifo.queue\[1\]\[6\] VGND VGND VPWR VPWR net795 sky130_fd_sc_hd__dlygate4sd3_1
XFILLER_98_610 VGND VGND VPWR VPWR sky130_fd_sc_hd__fill_1
X_4393_ clknet_leaf_78_clk _0450_ VGND VGND VPWR VPWR lsu.load_fifo.queue\[5\]\[1\]
+ sky130_fd_sc_hd__dfxtp_1
X_3344_ net872 net302 net175 VGND VGND VPWR VPWR _0954_ sky130_fd_sc_hd__mux2_1
X_3275_ net644 net288 _2053_ VGND VGND VPWR VPWR _0838_ sky130_fd_sc_hd__mux2_1
XFILLER_58_529 VGND VGND VPWR VPWR sky130_fd_sc_hd__decap_3
X_2226_ net478 net165 _1669_ net245 lsu.load_counter\[6\] VGND VGND VPWR VPWR _1701_
+ sky130_fd_sc_hd__o2111a_1
X_5014_ clknet_leaf_60_clk _1069_ VGND VGND VPWR VPWR lsu.store_fifo.queue\[13\]\[3\]
+ sky130_fd_sc_hd__dfxtp_1
X_2157_ lsu.load_counter\[15\] _1586_ _1587_ net470 lsu.load_counter\[14\] VGND VGND
+ VPWR VPWR _1647_ sky130_fd_sc_hd__a221o_1
XTAP_TAPCELL_ROW_49_771 VGND VPWR sky130_fd_sc_hd__tapvpwrvgnd_1
XFILLER_53_223 VGND VGND VPWR VPWR sky130_fd_sc_hd__fill_1
X_2088_ _1565_ _1577_ VGND VGND VPWR VPWR _1578_ sky130_fd_sc_hd__and2_1
X_4729_ clknet_leaf_38_clk net667 VGND VGND VPWR VPWR net116 sky130_fd_sc_hd__dfxtp_1
XFILLER_5_319 VGND VGND VPWR VPWR sky130_fd_sc_hd__fill_1
XFILLER_101_6 VPWR VGND VPWR VGND sky130_ef_sc_hd__decap_12
XFILLER_1_503 VGND VGND VPWR VPWR sky130_fd_sc_hd__fill_1
XFILLER_67_46 VGND VGND VPWR VPWR sky130_fd_sc_hd__decap_8
XFILLER_67_57 VGND VGND VPWR VPWR sky130_fd_sc_hd__decap_8
XFILLER_76_348 VPWR VGND VPWR VGND sky130_ef_sc_hd__decap_12
XFILLER_29_253 VGND VGND VPWR VPWR sky130_fd_sc_hd__decap_3
XFILLER_72_554 VGND VGND VPWR VPWR sky130_fd_sc_hd__decap_8
XFILLER_44_245 VGND VGND VPWR VPWR sky130_fd_sc_hd__fill_2
XFILLER_12_153 VGND VGND VPWR VPWR sky130_fd_sc_hd__decap_4
Xlsu_wrapper_457 VGND VGND VPWR VPWR lsu_wrapper_457/HI store_data[20] sky130_fd_sc_hd__conb_1
Xlsu_wrapper_468 VGND VGND VPWR VPWR lsu_wrapper_468/HI store_data[31] sky130_fd_sc_hd__conb_1
XFILLER_12_197 VGND VGND VPWR VPWR sky130_fd_sc_hd__decap_6
XTAP_TAPCELL_ROW_10_343 VGND VPWR sky130_fd_sc_hd__tapvpwrvgnd_1
XTAP_TAPCELL_ROW_74_1039 VGND VPWR sky130_fd_sc_hd__tapvpwrvgnd_1
XFILLER_4_363 VGND VGND VPWR VPWR sky130_fd_sc_hd__fill_1
X_3060_ net1163 net314 net206 VGND VGND VPWR VPWR _0565_ sky130_fd_sc_hd__mux2_1
XFILLER_82_307 VGND VGND VPWR VPWR sky130_fd_sc_hd__fill_1
XFILLER_75_370 VGND VGND VPWR VPWR sky130_fd_sc_hd__fill_1
XTAP_TAPCELL_ROW_18_432 VGND VPWR sky130_fd_sc_hd__tapvpwrvgnd_1
XTAP_TAPCELL_ROW_46_741 VGND VPWR sky130_fd_sc_hd__tapvpwrvgnd_1
XTAP_TAPCELL_ROW_85_1168 VGND VPWR sky130_fd_sc_hd__tapvpwrvgnd_1
X_3962_ lsu.load_fifo.queue\[4\]\[5\] lsu.load_fifo.queue\[5\]\[5\] lsu.load_fifo.queue\[6\]\[5\]
+ lsu.load_fifo.queue\[7\]\[5\] net391 net374 VGND VGND VPWR VPWR _1408_ sky130_fd_sc_hd__mux4_1
X_3893_ lsu.load_fifo.queue\[4\]\[15\] lsu.load_fifo.queue\[5\]\[15\] lsu.load_fifo.queue\[6\]\[15\]
+ lsu.load_fifo.queue\[7\]\[15\] net395 net378 VGND VGND VPWR VPWR _1349_ sky130_fd_sc_hd__mux4_1
X_2913_ net984 net338 net221 VGND VGND VPWR VPWR _0425_ sky130_fd_sc_hd__mux2_1
XFILLER_31_484 VGND VGND VPWR VPWR sky130_fd_sc_hd__decap_3
X_2844_ net844 net347 net224 VGND VGND VPWR VPWR _0355_ sky130_fd_sc_hd__mux2_1
X_2775_ net286 net1203 _2030_ VGND VGND VPWR VPWR _0291_ sky130_fd_sc_hd__mux2_1
X_4514_ clknet_leaf_7_clk _0571_ VGND VGND VPWR VPWR lsu.load_fifo.queue\[2\]\[26\]
+ sky130_fd_sc_hd__dfxtp_1
XTAP_TAPCELL_ROW_96_1286 VGND VPWR sky130_fd_sc_hd__tapvpwrvgnd_1
Xhold113 lsu.load_fifo.queue\[3\]\[0\] VGND VGND VPWR VPWR net581 sky130_fd_sc_hd__dlygate4sd3_1
Xhold124 lsu.load_fifo.queue\[12\]\[14\] VGND VGND VPWR VPWR net592 sky130_fd_sc_hd__dlygate4sd3_1
Xhold102 lsu.load_fifo.queue\[3\]\[1\] VGND VGND VPWR VPWR net570 sky130_fd_sc_hd__dlygate4sd3_1
Xhold135 lsu.load_fifo.queue\[15\]\[5\] VGND VGND VPWR VPWR net603 sky130_fd_sc_hd__dlygate4sd3_1
Xhold157 net121 VGND VGND VPWR VPWR net625 sky130_fd_sc_hd__dlygate4sd3_1
X_4445_ clknet_leaf_14_clk _0502_ VGND VGND VPWR VPWR lsu.load_fifo.queue\[4\]\[21\]
+ sky130_fd_sc_hd__dfxtp_1
Xhold146 lsu.store_fifo.queue\[14\]\[0\] VGND VGND VPWR VPWR net614 sky130_fd_sc_hd__dlygate4sd3_1
Xhold168 lsu.load_fifo.queue\[3\]\[30\] VGND VGND VPWR VPWR net636 sky130_fd_sc_hd__dlygate4sd3_1
X_4376_ clknet_leaf_31_clk _0433_ VGND VGND VPWR VPWR lsu.load_fifo.queue\[6\]\[16\]
+ sky130_fd_sc_hd__dfxtp_1
Xhold179 lsu.load_fifo.queue\[4\]\[0\] VGND VGND VPWR VPWR net647 sky130_fd_sc_hd__dlygate4sd3_1
XPHY_EDGE_ROW_13_Left_120 VGND VGND VPWR VPWR sky130_fd_sc_hd__decap_3
X_3327_ net537 net337 net174 VGND VGND VPWR VPWR _0937_ sky130_fd_sc_hd__mux2_1
XFILLER_85_156 VGND VGND VPWR VPWR sky130_fd_sc_hd__fill_1
X_3258_ lsu.current_store_addr\[7\] net817 net257 VGND VGND VPWR VPWR _0818_ sky130_fd_sc_hd__mux2_1
X_2209_ _1100_ _1673_ VGND VGND VPWR VPWR _1691_ sky130_fd_sc_hd__and2_1
X_3189_ net1195 net320 net203 VGND VGND VPWR VPWR _0690_ sky130_fd_sc_hd__mux2_1
XFILLER_14_418 VGND VGND VPWR VPWR sky130_fd_sc_hd__fill_2
XTAP_TAPCELL_ROW_105_1382 VGND VPWR sky130_fd_sc_hd__tapvpwrvgnd_1
XFILLER_10_613 VPWR VGND VPWR VGND sky130_ef_sc_hd__decap_12
XTAP_TAPCELL_ROW_52_799 VGND VPWR sky130_fd_sc_hd__tapvpwrvgnd_1
Xhold680 lsu.load_fifo.queue\[5\]\[21\] VGND VGND VPWR VPWR net1148 sky130_fd_sc_hd__dlygate4sd3_1
Xhold691 lsu.load_fifo.queue\[1\]\[5\] VGND VGND VPWR VPWR net1159 sky130_fd_sc_hd__dlygate4sd3_1
XFILLER_49_337 VGND VGND VPWR VPWR sky130_fd_sc_hd__fill_1
XFILLER_94_77 VGND VGND VPWR VPWR sky130_fd_sc_hd__decap_6
XFILLER_91_137 VGND VGND VPWR VPWR sky130_fd_sc_hd__decap_6
XFILLER_45_532 VGND VGND VPWR VPWR sky130_fd_sc_hd__decap_8
XTAP_TAPCELL_ROW_43_700 VGND VPWR sky130_fd_sc_hd__tapvpwrvgnd_1
XFILLER_45_565 VGND VGND VPWR VPWR sky130_fd_sc_hd__fill_1
XFILLER_45_587 VGND VGND VPWR VPWR sky130_fd_sc_hd__decap_6
XFILLER_60_579 VGND VGND VPWR VPWR sky130_fd_sc_hd__decap_8
XFILLER_13_473 VPWR VGND VPWR VGND sky130_ef_sc_hd__decap_12
X_2560_ lsu.current_load_addr\[13\] _1957_ net161 VGND VGND VPWR VPWR _0740_ sky130_fd_sc_hd__mux2_4
X_2491_ net91 net268 _1905_ VGND VGND VPWR VPWR _1907_ sky130_fd_sc_hd__o21ba_1
X_4230_ clknet_leaf_53_clk _0287_ VGND VGND VPWR VPWR lsu.store_fifo.queue\[4\]\[8\]
+ sky130_fd_sc_hd__dfxtp_1
X_4161_ clknet_leaf_27_clk _0218_ VGND VGND VPWR VPWR lsu.load_fifo.queue\[11\]\[21\]
+ sky130_fd_sc_hd__dfxtp_1
XFILLER_4_53 VPWR VGND VPWR VGND sky130_ef_sc_hd__decap_12
XFILLER_4_97 VGND VGND VPWR VPWR sky130_fd_sc_hd__fill_1
X_3112_ net874 net343 net181 VGND VGND VPWR VPWR _0615_ sky130_fd_sc_hd__mux2_1
X_4092_ net402 _1522_ net405 VGND VGND VPWR VPWR _1525_ sky130_fd_sc_hd__o21ai_1
XFILLER_95_498 VGND VGND VPWR VPWR sky130_fd_sc_hd__decap_3
X_3043_ net726 net349 net206 VGND VGND VPWR VPWR _0548_ sky130_fd_sc_hd__mux2_1
XFILLER_36_521 VGND VGND VPWR VPWR sky130_fd_sc_hd__fill_1
XFILLER_55_329 VGND VGND VPWR VPWR sky130_fd_sc_hd__decap_6
XFILLER_67_178 VGND VGND VPWR VPWR sky130_fd_sc_hd__decap_8
XFILLER_82_137 VGND VGND VPWR VPWR sky130_fd_sc_hd__decap_3
XFILLER_36_543 VGND VGND VPWR VPWR sky130_fd_sc_hd__decap_6
XFILLER_51_502 VGND VGND VPWR VPWR sky130_fd_sc_hd__fill_2
XFILLER_63_351 VGND VGND VPWR VPWR sky130_fd_sc_hd__decap_3
XFILLER_90_181 VPWR VGND VPWR VGND sky130_ef_sc_hd__decap_12
XFILLER_23_237 VGND VGND VPWR VPWR sky130_fd_sc_hd__decap_6
X_4994_ clknet_leaf_10_clk _1049_ VGND VGND VPWR VPWR lsu.load_fifo.queue\[14\]\[15\]
+ sky130_fd_sc_hd__dfxtp_1
X_3945_ net1289 _1393_ net255 VGND VGND VPWR VPWR _1010_ sky130_fd_sc_hd__mux2_1
XFILLER_51_557 VGND VGND VPWR VPWR sky130_fd_sc_hd__decap_3
XFILLER_51_579 VGND VGND VPWR VPWR sky130_fd_sc_hd__fill_1
XTAP_TAPCELL_ROW_98_1304 VGND VPWR sky130_fd_sc_hd__tapvpwrvgnd_1
X_3876_ _1332_ _1334_ _1331_ _1333_ net356 net362 VGND VGND VPWR VPWR _1335_ sky130_fd_sc_hd__mux4_1
X_2827_ net313 net1081 net228 VGND VGND VPWR VPWR _0340_ sky130_fd_sc_hd__mux2_1
XFILLER_3_609 VGND VGND VPWR VPWR sky130_fd_sc_hd__decap_6
X_2758_ net274 net1105 _2027_ VGND VGND VPWR VPWR _0277_ sky130_fd_sc_hd__mux2_1
X_2689_ net695 net323 net232 VGND VGND VPWR VPWR _0213_ sky130_fd_sc_hd__mux2_1
X_4428_ clknet_leaf_19_clk _0485_ VGND VGND VPWR VPWR lsu.load_fifo.queue\[4\]\[4\]
+ sky130_fd_sc_hd__dfxtp_1
Xfanout412 net413 VGND VGND VPWR VPWR net412 sky130_fd_sc_hd__buf_4
Xfanout423 net446 VGND VGND VPWR VPWR net423 sky130_fd_sc_hd__clkbuf_4
Xfanout401 net402 VGND VGND VPWR VPWR net401 sky130_fd_sc_hd__clkbuf_4
X_4359_ clknet_leaf_37_clk _0416_ _0003_ VGND VGND VPWR VPWR lsu.loader_state\[1\]
+ sky130_fd_sc_hd__dfrtp_1
XFILLER_86_432 VGND VGND VPWR VPWR sky130_fd_sc_hd__fill_2
Xfanout434 net445 VGND VGND VPWR VPWR net434 sky130_fd_sc_hd__buf_2
Xfanout445 net446 VGND VGND VPWR VPWR net445 sky130_fd_sc_hd__buf_2
XFILLER_100_253 VGND VGND VPWR VPWR sky130_fd_sc_hd__fill_1
XFILLER_58_167 VGND VGND VPWR VPWR sky130_fd_sc_hd__decap_6
XFILLER_27_554 VGND VGND VPWR VPWR sky130_fd_sc_hd__decap_6
XTAP_TAPCELL_ROW_29_549 VGND VPWR sky130_fd_sc_hd__tapvpwrvgnd_1
XTAP_TAPCELL_ROW_57_858 VGND VPWR sky130_fd_sc_hd__tapvpwrvgnd_1
XFILLER_14_226 VGND VGND VPWR VPWR sky130_fd_sc_hd__fill_1
XFILLER_14_215 VGND VGND VPWR VPWR sky130_fd_sc_hd__fill_2
XFILLER_10_421 VPWR VGND VPWR VGND sky130_ef_sc_hd__decap_12
XFILLER_6_469 VGND VGND VPWR VPWR sky130_fd_sc_hd__decap_6
XFILLER_89_55 VGND VGND VPWR VPWR sky130_fd_sc_hd__fill_1
XTAP_TAPCELL_ROW_71_1009 VGND VPWR sky130_fd_sc_hd__tapvpwrvgnd_1
XFILLER_89_281 VPWR VGND VPWR VGND sky130_ef_sc_hd__decap_12
XFILLER_77_432 VPWR VGND VPWR VGND sky130_ef_sc_hd__decap_12
XFILLER_77_476 VPWR VGND VPWR VGND sky130_ef_sc_hd__decap_12
XFILLER_64_115 VGND VGND VPWR VPWR sky130_fd_sc_hd__fill_2
XFILLER_18_521 VGND VGND VPWR VPWR sky130_fd_sc_hd__decap_8
XFILLER_33_513 VGND VGND VPWR VPWR sky130_fd_sc_hd__decap_8
XTAP_TAPCELL_ROW_82_1127 VGND VPWR sky130_fd_sc_hd__tapvpwrvgnd_1
XFILLER_20_229 VGND VGND VPWR VPWR sky130_fd_sc_hd__decap_6
X_3730_ _1206_ _1211_ VGND VGND VPWR VPWR _1212_ sky130_fd_sc_hd__nor2_1
XFILLER_13_281 VPWR VGND VPWR VGND sky130_ef_sc_hd__decap_12
X_3661_ acc.byte1\[0\] acc.byte0\[0\] VGND VGND VPWR VPWR _1143_ sky130_fd_sc_hd__and2_1
Xclkload44 clknet_leaf_14_clk VGND VGND VPWR VPWR clkload44/Y sky130_fd_sc_hd__inv_6
X_3592_ net424 VGND VGND VPWR VPWR _0156_ sky130_fd_sc_hd__inv_2
Xclkload22 clknet_leaf_75_clk VGND VGND VPWR VPWR clkload22/Y sky130_fd_sc_hd__inv_6
Xclkload11 clknet_leaf_4_clk VGND VGND VPWR VPWR clkload11/Y sky130_fd_sc_hd__bufinv_16
X_2612_ _1993_ _1994_ VGND VGND VPWR VPWR _0715_ sky130_fd_sc_hd__and2_1
Xclkload33 clknet_leaf_18_clk VGND VGND VPWR VPWR clkload33/Y sky130_fd_sc_hd__clkinvlp_4
XFILLER_62_3 VGND VGND VPWR VPWR sky130_fd_sc_hd__fill_1
X_2543_ net32 net260 _1943_ _1944_ VGND VGND VPWR VPWR _1945_ sky130_fd_sc_hd__a22o_1
Xclkload77 clknet_leaf_41_clk VGND VGND VPWR VPWR clkload77/Y sky130_fd_sc_hd__clkinv_8
Xclkload66 clknet_leaf_66_clk VGND VGND VPWR VPWR clkload66/Y sky130_fd_sc_hd__inv_6
Xclkload55 clknet_leaf_70_clk VGND VGND VPWR VPWR clkload55/X sky130_fd_sc_hd__clkbuf_4
XTAP_TAPCELL_ROW_93_1256 VGND VPWR sky130_fd_sc_hd__tapvpwrvgnd_1
X_2474_ _1892_ _1894_ _1895_ lsu.current_store_addr\[7\] VGND VGND VPWR VPWR _0796_
+ sky130_fd_sc_hd__o2bb2a_1
XFILLER_68_421 VPWR VGND VPWR VGND sky130_ef_sc_hd__decap_12
X_4213_ clknet_leaf_59_clk _0270_ VGND VGND VPWR VPWR lsu.store_fifo.queue\[5\]\[1\]
+ sky130_fd_sc_hd__dfxtp_1
X_4144_ clknet_leaf_18_clk _0201_ VGND VGND VPWR VPWR lsu.load_fifo.queue\[11\]\[4\]
+ sky130_fd_sc_hd__dfxtp_1
XFILLER_95_273 VGND VGND VPWR VPWR sky130_fd_sc_hd__decap_6
X_4075_ net400 _1508_ VGND VGND VPWR VPWR _1509_ sky130_fd_sc_hd__nor2_1
XTAP_TAPCELL_ROW_26_519 VGND VPWR sky130_fd_sc_hd__tapvpwrvgnd_1
X_3026_ net628 net316 net210 VGND VGND VPWR VPWR _0532_ sky130_fd_sc_hd__mux2_1
XTAP_TAPCELL_ROW_54_828 VGND VPWR sky130_fd_sc_hd__tapvpwrvgnd_1
XTAP_TAPCELL_ROW_102_1352 VGND VPWR sky130_fd_sc_hd__tapvpwrvgnd_1
X_4977_ clknet_leaf_11_clk _1032_ _0163_ VGND VGND VPWR VPWR acc.byte3\[6\] sky130_fd_sc_hd__dfrtp_1
X_3928_ lsu.load_fifo.queue\[12\]\[10\] lsu.load_fifo.queue\[13\]\[10\] lsu.load_fifo.queue\[14\]\[10\]
+ lsu.load_fifo.queue\[15\]\[10\] net393 net376 VGND VGND VPWR VPWR _1379_ sky130_fd_sc_hd__mux4_1
Xclkload5 clknet_3_6__leaf_clk VGND VGND VPWR VPWR clkload5/Y sky130_fd_sc_hd__inv_6
X_3859_ lsu.load_fifo.queue\[0\]\[20\] lsu.load_fifo.queue\[1\]\[20\] lsu.load_fifo.queue\[2\]\[20\]
+ lsu.load_fifo.queue\[3\]\[20\] net384 net367 VGND VGND VPWR VPWR _1320_ sky130_fd_sc_hd__mux4_1
XFILLER_50_49 VGND VGND VPWR VPWR sky130_fd_sc_hd__fill_2
XFILLER_3_417 VPWR VGND VPWR VGND sky130_ef_sc_hd__decap_12
XFILLER_105_334 VGND VGND VPWR VPWR sky130_fd_sc_hd__fill_2
Xfanout220 _2036_ VGND VGND VPWR VPWR net220 sky130_fd_sc_hd__buf_4
Xfanout231 _2022_ VGND VGND VPWR VPWR net231 sky130_fd_sc_hd__clkbuf_4
Xfanout264 _1547_ VGND VGND VPWR VPWR net264 sky130_fd_sc_hd__clkbuf_4
Xfanout242 _1723_ VGND VGND VPWR VPWR net242 sky130_fd_sc_hd__clkbuf_2
Xfanout253 net254 VGND VGND VPWR VPWR net253 sky130_fd_sc_hd__clkbuf_4
Xfanout297 lsu.load_fifo.data_in\[29\] VGND VGND VPWR VPWR net297 sky130_fd_sc_hd__clkbuf_2
XTAP_TAPCELL_ROW_6_299 VGND VPWR sky130_fd_sc_hd__tapvpwrvgnd_1
Xfanout286 acc.data_out\[2\] VGND VGND VPWR VPWR net286 sky130_fd_sc_hd__clkbuf_2
Xfanout275 acc.data_out\[8\] VGND VGND VPWR VPWR net275 sky130_fd_sc_hd__dlymetal6s2s_1
XFILLER_74_457 VPWR VGND VPWR VGND sky130_ef_sc_hd__decap_12
XFILLER_46_159 VGND VGND VPWR VPWR sky130_fd_sc_hd__fill_1
XFILLER_61_107 VGND VGND VPWR VPWR sky130_fd_sc_hd__decap_4
XFILLER_27_384 VGND VGND VPWR VPWR sky130_fd_sc_hd__decap_8
Xclkbuf_leaf_81_clk clknet_3_1__leaf_clk VGND VGND VPWR VPWR clknet_leaf_81_clk sky130_fd_sc_hd__clkbuf_8
XFILLER_54_192 VGND VGND VPWR VPWR sky130_fd_sc_hd__decap_4
XFILLER_23_590 VPWR VGND VPWR VGND sky130_ef_sc_hd__decap_12
XFILLER_6_211 VPWR VGND VPWR VGND sky130_ef_sc_hd__decap_12
XFILLER_97_505 VGND VGND VPWR VPWR sky130_fd_sc_hd__decap_8
XFILLER_69_229 VGND VGND VPWR VPWR sky130_fd_sc_hd__fill_1
X_2190_ _1096_ _1678_ net160 _1677_ VGND VGND VPWR VPWR _0927_ sky130_fd_sc_hd__a2bb2o_4
XFILLER_77_262 VGND VGND VPWR VPWR sky130_fd_sc_hd__fill_1
XFILLER_92_221 VPWR VGND VPWR VGND sky130_ef_sc_hd__decap_12
XFILLER_92_265 VPWR VGND VPWR VGND sky130_ef_sc_hd__decap_12
XFILLER_80_416 VGND VGND VPWR VPWR sky130_fd_sc_hd__decap_4
XFILLER_18_362 VGND VGND VPWR VPWR sky130_fd_sc_hd__fill_2
XFILLER_65_479 VGND VGND VPWR VPWR sky130_fd_sc_hd__fill_1
X_4900_ clknet_leaf_80_clk _0955_ VGND VGND VPWR VPWR lsu.load_fifo.queue\[12\]\[27\]
+ sky130_fd_sc_hd__dfxtp_1
X_4831_ clknet_leaf_36_clk _0888_ _0081_ VGND VGND VPWR VPWR lsu.store_counter\[8\]
+ sky130_fd_sc_hd__dfrtp_1
Xclkbuf_leaf_72_clk clknet_3_4__leaf_clk VGND VGND VPWR VPWR clknet_leaf_72_clk sky130_fd_sc_hd__clkbuf_8
X_4762_ clknet_leaf_63_clk net704 VGND VGND VPWR VPWR net147 sky130_fd_sc_hd__dfxtp_1
XFILLER_60_195 VGND VGND VPWR VPWR sky130_fd_sc_hd__fill_1
XTAP_TAPCELL_ROW_31_566 VGND VPWR sky130_fd_sc_hd__tapvpwrvgnd_1
X_3713_ _1192_ _1194_ _1191_ VGND VGND VPWR VPWR _1195_ sky130_fd_sc_hd__a21boi_1
X_4693_ clknet_leaf_11_clk _0750_ _0039_ VGND VGND VPWR VPWR lsu.load_fifo.r_ptr\[1\]
+ sky130_fd_sc_hd__dfrtp_1
X_3644_ _1107_ acc.state VGND VGND VPWR VPWR _1126_ sky130_fd_sc_hd__or2_2
X_3575_ net422 VGND VGND VPWR VPWR _0139_ sky130_fd_sc_hd__inv_2
X_2526_ lsu.current_load_addr\[20\] lsu.current_load_addr\[19\] _1931_ VGND VGND VPWR
+ VPWR _1932_ sky130_fd_sc_hd__and3_1
X_2457_ lsu.current_store_addr\[10\] lsu.current_store_addr\[9\] _1847_ net265 VGND
+ VGND VPWR VPWR _1883_ sky130_fd_sc_hd__a31o_1
X_2388_ _1782_ _1826_ VGND VGND VPWR VPWR _1827_ sky130_fd_sc_hd__nor2_1
XFILLER_68_251 VGND VGND VPWR VPWR sky130_fd_sc_hd__fill_1
Xhold39 lsu.store_fifo.queue\[8\]\[4\] VGND VGND VPWR VPWR net507 sky130_fd_sc_hd__dlygate4sd3_1
XTAP_TAPCELL_ROW_3_258 VGND VPWR sky130_fd_sc_hd__tapvpwrvgnd_1
X_4127_ clknet_leaf_66_clk _0184_ VGND VGND VPWR VPWR lsu.store_fifo.queue\[11\]\[7\]
+ sky130_fd_sc_hd__dfxtp_1
X_4058_ net270 _1493_ VGND VGND VPWR VPWR _1494_ sky130_fd_sc_hd__nor2_1
XTAP_TAPCELL_ROW_39_655 VGND VPWR sky130_fd_sc_hd__tapvpwrvgnd_1
XTAP_TAPCELL_ROW_67_964 VGND VPWR sky130_fd_sc_hd__tapvpwrvgnd_1
X_3009_ net525 net351 net212 VGND VGND VPWR VPWR _0515_ sky130_fd_sc_hd__mux2_1
XFILLER_71_449 VPWR VGND VPWR VGND sky130_ef_sc_hd__decap_12
XFILLER_36_181 VGND VGND VPWR VPWR sky130_fd_sc_hd__fill_2
Xclkbuf_leaf_63_clk clknet_3_5__leaf_clk VGND VGND VPWR VPWR clknet_leaf_63_clk sky130_fd_sc_hd__clkbuf_8
XFILLER_101_99 VGND VGND VPWR VPWR sky130_fd_sc_hd__fill_1
XPHY_EDGE_ROW_5_Left_112 VGND VGND VPWR VPWR sky130_fd_sc_hd__decap_3
XFILLER_105_142 VGND VGND VPWR VPWR sky130_fd_sc_hd__decap_4
XFILLER_3_258 VGND VGND VPWR VPWR sky130_fd_sc_hd__fill_1
XFILLER_101_370 VGND VGND VPWR VPWR sky130_fd_sc_hd__decap_4
XFILLER_19_94 VGND VGND VPWR VPWR sky130_fd_sc_hd__fill_1
XFILLER_62_416 VGND VGND VPWR VPWR sky130_fd_sc_hd__decap_4
Xclkbuf_leaf_54_clk clknet_3_6__leaf_clk VGND VGND VPWR VPWR clknet_leaf_54_clk sky130_fd_sc_hd__clkbuf_8
XFILLER_51_81 VGND VGND VPWR VPWR sky130_fd_sc_hd__fill_1
Xhold509 lsu.store_fifo.queue\[11\]\[0\] VGND VGND VPWR VPWR net977 sky130_fd_sc_hd__dlygate4sd3_1
XFILLER_7_553 VGND VGND VPWR VPWR sky130_fd_sc_hd__decap_6
XFILLER_7_597 VPWR VGND VPWR VGND sky130_ef_sc_hd__decap_12
XTAP_TAPCELL_ROW_90_1215 VGND VPWR sky130_fd_sc_hd__tapvpwrvgnd_1
X_3360_ net337 net1074 net170 VGND VGND VPWR VPWR _0969_ sky130_fd_sc_hd__mux2_1
X_2311_ _1758_ _1760_ VGND VGND VPWR VPWR _0887_ sky130_fd_sc_hd__and2_1
XFILLER_97_335 VGND VGND VPWR VPWR sky130_fd_sc_hd__fill_1
X_3291_ net342 net75 net248 VGND VGND VPWR VPWR _0853_ sky130_fd_sc_hd__mux2_1
X_5030_ clknet_leaf_73_clk _1085_ _0174_ VGND VGND VPWR VPWR acc.data_out\[9\] sky130_fd_sc_hd__dfrtp_1
X_2242_ net478 net480 lsu.load_counter\[0\] net243 VGND VGND VPWR VPWR _1711_ sky130_fd_sc_hd__o211a_1
XFILLER_25_3 VGND VGND VPWR VPWR sky130_fd_sc_hd__decap_6
X_2173_ _1661_ _1573_ _1662_ _1569_ VGND VGND VPWR VPWR _1663_ sky130_fd_sc_hd__o2bb2a_4
XFILLER_65_221 VGND VGND VPWR VPWR sky130_fd_sc_hd__decap_3
XFILLER_93_574 VGND VGND VPWR VPWR sky130_fd_sc_hd__decap_8
XPHY_EDGE_ROW_69_Left_176 VGND VGND VPWR VPWR sky130_fd_sc_hd__decap_3
XTAP_TAPCELL_ROW_0_217 VGND VPWR sky130_fd_sc_hd__tapvpwrvgnd_1
XTAP_TAPCELL_ROW_88_1199 VGND VPWR sky130_fd_sc_hd__tapvpwrvgnd_1
XTAP_TAPCELL_ROW_0_228 VGND VPWR sky130_fd_sc_hd__tapvpwrvgnd_1
XTAP_TAPCELL_ROW_36_625 VGND VPWR sky130_fd_sc_hd__tapvpwrvgnd_1
XTAP_TAPCELL_ROW_64_934 VGND VPWR sky130_fd_sc_hd__tapvpwrvgnd_1
Xclkbuf_leaf_45_clk clknet_3_7__leaf_clk VGND VGND VPWR VPWR clknet_leaf_45_clk sky130_fd_sc_hd__clkbuf_8
X_4814_ clknet_leaf_37_clk _0871_ VGND VGND VPWR VPWR lsu.load_fifo.data_in\[24\]
+ sky130_fd_sc_hd__dfxtp_1
XFILLER_61_493 VGND VGND VPWR VPWR sky130_fd_sc_hd__fill_1
X_4745_ clknet_leaf_48_clk _0802_ _0059_ VGND VGND VPWR VPWR lsu.current_store_addr\[13\]
+ sky130_fd_sc_hd__dfrtp_1
X_4676_ clknet_leaf_29_clk _0733_ _0022_ VGND VGND VPWR VPWR lsu.current_load_addr\[6\]
+ sky130_fd_sc_hd__dfrtp_1
XPHY_EDGE_ROW_78_Left_185 VGND VGND VPWR VPWR sky130_fd_sc_hd__decap_3
X_3627_ lsu.current_store_addr\[2\] VGND VGND VPWR VPWR _1110_ sky130_fd_sc_hd__inv_2
X_3558_ net443 VGND VGND VPWR VPWR _0122_ sky130_fd_sc_hd__inv_2
XTAP_TAPCELL_ROW_8_317 VGND VPWR sky130_fd_sc_hd__tapvpwrvgnd_1
XFILLER_88_302 VGND VGND VPWR VPWR sky130_fd_sc_hd__decap_6
X_2509_ _1916_ _1917_ VGND VGND VPWR VPWR _0751_ sky130_fd_sc_hd__and2_1
XFILLER_88_357 VGND VGND VPWR VPWR sky130_fd_sc_hd__decap_6
XFILLER_76_508 VPWR VGND VPWR VGND sky130_ef_sc_hd__decap_12
X_3489_ net432 VGND VGND VPWR VPWR _0053_ sky130_fd_sc_hd__inv_2
XPHY_EDGE_ROW_87_Left_194 VGND VGND VPWR VPWR sky130_fd_sc_hd__decap_3
XFILLER_44_405 VGND VGND VPWR VPWR sky130_fd_sc_hd__decap_4
XFILLER_56_232 VGND VGND VPWR VPWR sky130_fd_sc_hd__decap_8
XFILLER_71_202 VGND VGND VPWR VPWR sky130_fd_sc_hd__fill_1
XFILLER_44_427 VGND VGND VPWR VPWR sky130_fd_sc_hd__fill_1
Xclkbuf_leaf_36_clk clknet_3_6__leaf_clk VGND VGND VPWR VPWR clknet_leaf_36_clk sky130_fd_sc_hd__clkbuf_8
XFILLER_71_279 VGND VGND VPWR VPWR sky130_fd_sc_hd__fill_1
XFILLER_4_501 VPWR VGND VPWR VGND sky130_ef_sc_hd__decap_12
XFILLER_21_51 VGND VGND VPWR VPWR sky130_fd_sc_hd__decap_4
XFILLER_4_545 VPWR VGND VPWR VGND sky130_ef_sc_hd__decap_12
XFILLER_97_55 VGND VGND VPWR VPWR sky130_fd_sc_hd__fill_1
XTAP_TAPCELL_ROW_76_1070 VGND VPWR sky130_fd_sc_hd__tapvpwrvgnd_1
XFILLER_4_589 VPWR VGND VPWR VGND sky130_ef_sc_hd__decap_12
XFILLER_67_508 VPWR VGND VPWR VGND sky130_ef_sc_hd__decap_12
XFILLER_90_555 VGND VGND VPWR VPWR sky130_fd_sc_hd__fill_2
Xclkbuf_leaf_27_clk clknet_3_3__leaf_clk VGND VGND VPWR VPWR clknet_leaf_27_clk sky130_fd_sc_hd__clkbuf_8
XFILLER_35_449 VGND VGND VPWR VPWR sky130_fd_sc_hd__decap_4
XTAP_TAPCELL_ROW_61_904 VGND VPWR sky130_fd_sc_hd__tapvpwrvgnd_1
X_2860_ net720 net315 net222 VGND VGND VPWR VPWR _0371_ sky130_fd_sc_hd__mux2_1
XTAP_TAPCELL_ROW_13_374 VGND VPWR sky130_fd_sc_hd__tapvpwrvgnd_1
X_2791_ net761 net277 _2031_ VGND VGND VPWR VPWR _0306_ sky130_fd_sc_hd__mux2_1
XTAP_TAPCELL_ROW_41_683 VGND VPWR sky130_fd_sc_hd__tapvpwrvgnd_1
X_4530_ clknet_leaf_23_clk _0587_ VGND VGND VPWR VPWR lsu.load_fifo.queue\[1\]\[10\]
+ sky130_fd_sc_hd__dfxtp_1
Xhold317 lsu.load_fifo.queue\[3\]\[10\] VGND VGND VPWR VPWR net785 sky130_fd_sc_hd__dlygate4sd3_1
Xhold306 lsu.load_fifo.queue\[11\]\[17\] VGND VGND VPWR VPWR net774 sky130_fd_sc_hd__dlygate4sd3_1
X_4461_ clknet_leaf_5_clk _0518_ VGND VGND VPWR VPWR lsu.load_fifo.queue\[3\]\[5\]
+ sky130_fd_sc_hd__dfxtp_1
Xhold328 lsu.load_fifo.queue\[2\]\[27\] VGND VGND VPWR VPWR net796 sky130_fd_sc_hd__dlygate4sd3_1
Xhold339 lsu.load_fifo.queue\[3\]\[18\] VGND VGND VPWR VPWR net807 sky130_fd_sc_hd__dlygate4sd3_1
X_3412_ net653 net298 net200 VGND VGND VPWR VPWR _1062_ sky130_fd_sc_hd__mux2_1
X_4392_ clknet_leaf_33_clk _0449_ VGND VGND VPWR VPWR lsu.load_fifo.queue\[5\]\[0\]
+ sky130_fd_sc_hd__dfxtp_1
X_3343_ net1223 net304 net174 VGND VGND VPWR VPWR _0953_ sky130_fd_sc_hd__mux2_1
X_3274_ net736 net290 _2053_ VGND VGND VPWR VPWR _0837_ sky130_fd_sc_hd__mux2_1
X_2225_ _1103_ _1699_ _1700_ net160 VGND VGND VPWR VPWR _0913_ sky130_fd_sc_hd__a2bb2o_4
X_5013_ clknet_leaf_61_clk _1068_ VGND VGND VPWR VPWR lsu.store_fifo.queue\[13\]\[2\]
+ sky130_fd_sc_hd__dfxtp_1
XFILLER_66_541 VGND VGND VPWR VPWR sky130_fd_sc_hd__decap_4
X_2156_ _1592_ _1595_ _1596_ _1590_ VGND VGND VPWR VPWR _1646_ sky130_fd_sc_hd__a211o_1
XFILLER_66_585 VGND VGND VPWR VPWR sky130_fd_sc_hd__decap_3
XFILLER_26_29 VGND VGND VPWR VPWR sky130_fd_sc_hd__fill_1
XTAP_TAPCELL_ROW_49_772 VGND VPWR sky130_fd_sc_hd__tapvpwrvgnd_1
X_2087_ net9 net8 _1563_ net10 VGND VGND VPWR VPWR _1577_ sky130_fd_sc_hd__o31ai_1
XPHY_EDGE_ROW_5_Right_5 VGND VGND VPWR VPWR sky130_fd_sc_hd__decap_3
Xclkbuf_leaf_18_clk clknet_3_2__leaf_clk VGND VGND VPWR VPWR clknet_leaf_18_clk sky130_fd_sc_hd__clkbuf_8
XFILLER_34_471 VGND VGND VPWR VPWR sky130_fd_sc_hd__decap_4
X_2989_ net747 net322 net192 VGND VGND VPWR VPWR _0497_ sky130_fd_sc_hd__mux2_1
X_4728_ clknet_leaf_43_clk _0785_ VGND VGND VPWR VPWR net114 sky130_fd_sc_hd__dfxtp_1
X_4659_ clknet_leaf_49_clk _0716_ _0015_ VGND VGND VPWR VPWR lsu.store_fifo.r_ptr\[3\]
+ sky130_fd_sc_hd__dfrtp_1
Xhold840 acc.byte0\[2\] VGND VGND VPWR VPWR net1308 sky130_fd_sc_hd__dlygate4sd3_1
XFILLER_88_121 VGND VGND VPWR VPWR sky130_fd_sc_hd__decap_8
XFILLER_1_559 VGND VGND VPWR VPWR sky130_fd_sc_hd__fill_1
XPHY_EDGE_ROW_95_Left_202 VGND VGND VPWR VPWR sky130_fd_sc_hd__decap_3
XFILLER_88_165 VGND VGND VPWR VPWR sky130_fd_sc_hd__decap_8
XFILLER_17_405 VPWR VGND VPWR VGND sky130_ef_sc_hd__decap_12
XFILLER_83_68 VGND VGND VPWR VPWR sky130_fd_sc_hd__fill_2
XFILLER_72_533 VGND VGND VPWR VPWR sky130_fd_sc_hd__decap_3
XFILLER_17_449 VPWR VGND VPWR VGND sky130_ef_sc_hd__decap_12
XFILLER_83_79 VPWR VGND VPWR VGND sky130_ef_sc_hd__decap_12
XFILLER_32_419 VGND VGND VPWR VPWR sky130_fd_sc_hd__fill_1
XFILLER_9_615 VGND VGND VPWR VPWR sky130_fd_sc_hd__fill_1
Xlsu_wrapper_447 VGND VGND VPWR VPWR lsu_wrapper_447/HI store_data[10] sky130_fd_sc_hd__conb_1
Xlsu_wrapper_458 VGND VGND VPWR VPWR lsu_wrapper_458/HI store_data[21] sky130_fd_sc_hd__conb_1
XFILLER_32_83 VGND VGND VPWR VPWR sky130_fd_sc_hd__fill_1
XTAP_TAPCELL_ROW_10_344 VGND VPWR sky130_fd_sc_hd__tapvpwrvgnd_1
XFILLER_106_281 VGND VGND VPWR VPWR sky130_fd_sc_hd__fill_2
XFILLER_95_614 VGND VGND VPWR VPWR sky130_fd_sc_hd__fill_2
XFILLER_0_581 VGND VGND VPWR VPWR sky130_fd_sc_hd__decap_3
XFILLER_35_202 VGND VGND VPWR VPWR sky130_fd_sc_hd__decap_3
XFILLER_75_393 VPWR VGND VPWR VGND sky130_ef_sc_hd__decap_12
XTAP_TAPCELL_ROW_18_433 VGND VPWR sky130_fd_sc_hd__tapvpwrvgnd_1
XTAP_TAPCELL_ROW_46_731 VGND VPWR sky130_fd_sc_hd__tapvpwrvgnd_1
XFILLER_90_363 VGND VGND VPWR VPWR sky130_fd_sc_hd__fill_1
XTAP_TAPCELL_ROW_85_1169 VGND VPWR sky130_fd_sc_hd__tapvpwrvgnd_1
X_3961_ net1259 _1407_ net253 VGND VGND VPWR VPWR _1008_ sky130_fd_sc_hd__mux2_1
X_2912_ net1026 net340 net221 VGND VGND VPWR VPWR _0424_ sky130_fd_sc_hd__mux2_1
XFILLER_92_3 VPWR VGND VPWR VGND sky130_ef_sc_hd__decap_12
X_3892_ _1346_ _1347_ net363 VGND VGND VPWR VPWR _1348_ sky130_fd_sc_hd__mux2_1
X_2843_ net851 net349 net222 VGND VGND VPWR VPWR _0354_ sky130_fd_sc_hd__mux2_1
X_2774_ net288 net1234 _2030_ VGND VGND VPWR VPWR _0290_ sky130_fd_sc_hd__mux2_1
X_4513_ clknet_leaf_68_clk _0570_ VGND VGND VPWR VPWR lsu.load_fifo.queue\[2\]\[25\]
+ sky130_fd_sc_hd__dfxtp_1
Xhold114 lsu.load_fifo.queue\[3\]\[28\] VGND VGND VPWR VPWR net582 sky130_fd_sc_hd__dlygate4sd3_1
Xhold103 lsu.load_fifo.queue\[10\]\[8\] VGND VGND VPWR VPWR net571 sky130_fd_sc_hd__dlygate4sd3_1
Xhold125 lsu.load_fifo.queue\[8\]\[4\] VGND VGND VPWR VPWR net593 sky130_fd_sc_hd__dlygate4sd3_1
XTAP_TAPCELL_ROW_96_1287 VGND VPWR sky130_fd_sc_hd__tapvpwrvgnd_1
Xhold147 lsu.load_fifo.queue\[0\]\[10\] VGND VGND VPWR VPWR net615 sky130_fd_sc_hd__dlygate4sd3_1
Xhold136 lsu.load_fifo.queue\[7\]\[27\] VGND VGND VPWR VPWR net604 sky130_fd_sc_hd__dlygate4sd3_1
X_4444_ clknet_leaf_82_clk _0501_ VGND VGND VPWR VPWR lsu.load_fifo.queue\[4\]\[20\]
+ sky130_fd_sc_hd__dfxtp_1
Xhold158 lsu.store_fifo.queue\[10\]\[3\] VGND VGND VPWR VPWR net626 sky130_fd_sc_hd__dlygate4sd3_1
Xclkbuf_leaf_7_clk clknet_3_0__leaf_clk VGND VGND VPWR VPWR clknet_leaf_7_clk sky130_fd_sc_hd__clkbuf_8
XFILLER_98_441 VGND VGND VPWR VPWR sky130_fd_sc_hd__fill_2
Xhold169 lsu.load_fifo.queue\[8\]\[23\] VGND VGND VPWR VPWR net637 sky130_fd_sc_hd__dlygate4sd3_1
X_4375_ clknet_leaf_11_clk _0432_ VGND VGND VPWR VPWR lsu.load_fifo.queue\[6\]\[15\]
+ sky130_fd_sc_hd__dfxtp_1
X_3326_ net650 net338 net176 VGND VGND VPWR VPWR _0936_ sky130_fd_sc_hd__mux2_1
XFILLER_85_113 VGND VGND VPWR VPWR sky130_fd_sc_hd__decap_6
XFILLER_58_338 VGND VGND VPWR VPWR sky130_fd_sc_hd__fill_2
X_3257_ lsu.current_store_addr\[6\] net721 net258 VGND VGND VPWR VPWR _0817_ sky130_fd_sc_hd__mux2_1
X_2208_ net479 net165 _1673_ net263 net244 VGND VGND VPWR VPWR _1690_ sky130_fd_sc_hd__o221a_1
X_3188_ net663 net322 net205 VGND VGND VPWR VPWR _0689_ sky130_fd_sc_hd__mux2_1
X_2139_ lsu.load_counter\[7\] _1619_ _1622_ lsu.load_counter\[4\] VGND VGND VPWR VPWR
+ _1629_ sky130_fd_sc_hd__a22oi_1
XTAP_TAPCELL_ROW_105_1383 VGND VPWR sky130_fd_sc_hd__tapvpwrvgnd_1
XFILLER_22_430 VGND VGND VPWR VPWR sky130_fd_sc_hd__decap_4
XFILLER_10_625 VGND VGND VPWR VPWR sky130_fd_sc_hd__fill_2
XFILLER_6_629 VGND VGND VPWR VPWR sky130_fd_sc_hd__fill_1
Xhold670 lsu.load_fifo.queue\[14\]\[21\] VGND VGND VPWR VPWR net1138 sky130_fd_sc_hd__dlygate4sd3_1
Xhold681 lsu.load_fifo.queue\[9\]\[11\] VGND VGND VPWR VPWR net1149 sky130_fd_sc_hd__dlygate4sd3_1
XFILLER_1_334 VGND VGND VPWR VPWR sky130_fd_sc_hd__fill_2
XFILLER_78_79 VGND VGND VPWR VPWR sky130_fd_sc_hd__decap_4
Xhold692 lsu.load_fifo.queue\[1\]\[23\] VGND VGND VPWR VPWR net1160 sky130_fd_sc_hd__dlygate4sd3_1
XFILLER_91_105 VGND VGND VPWR VPWR sky130_fd_sc_hd__decap_6
XFILLER_72_330 VGND VGND VPWR VPWR sky130_fd_sc_hd__decap_3
XTAP_TAPCELL_ROW_43_701 VGND VPWR sky130_fd_sc_hd__tapvpwrvgnd_1
XFILLER_13_441 VGND VGND VPWR VPWR sky130_fd_sc_hd__decap_6
XFILLER_13_485 VPWR VGND VPWR VGND sky130_ef_sc_hd__decap_12
XTAP_TAPCELL_ROW_23_480 VGND VPWR sky130_fd_sc_hd__tapvpwrvgnd_1
X_2490_ _1110_ _1903_ _1906_ _1723_ VGND VGND VPWR VPWR _0791_ sky130_fd_sc_hd__a2bb2o_1
X_4160_ clknet_leaf_85_clk _0217_ VGND VGND VPWR VPWR lsu.load_fifo.queue\[11\]\[20\]
+ sky130_fd_sc_hd__dfxtp_1
XFILLER_4_65 VPWR VGND VPWR VGND sky130_ef_sc_hd__decap_12
X_3111_ net635 net345 net183 VGND VGND VPWR VPWR _0614_ sky130_fd_sc_hd__mux2_1
X_4091_ net271 _1523_ VGND VGND VPWR VPWR _1524_ sky130_fd_sc_hd__nor2_1
X_3042_ net504 net351 net208 VGND VGND VPWR VPWR _0547_ sky130_fd_sc_hd__mux2_1
XFILLER_51_514 VPWR VGND VPWR VGND sky130_ef_sc_hd__decap_12
XFILLER_63_341 VGND VGND VPWR VPWR sky130_fd_sc_hd__fill_1
X_4993_ clknet_leaf_0_clk _1048_ VGND VGND VPWR VPWR lsu.load_fifo.queue\[14\]\[14\]
+ sky130_fd_sc_hd__dfxtp_1
XFILLER_90_193 VGND VGND VPWR VPWR sky130_fd_sc_hd__decap_3
X_3944_ _1390_ _1392_ _1389_ _1391_ net359 net363 VGND VGND VPWR VPWR _1393_ sky130_fd_sc_hd__mux4_1
X_3875_ lsu.load_fifo.queue\[8\]\[18\] lsu.load_fifo.queue\[9\]\[18\] lsu.load_fifo.queue\[10\]\[18\]
+ lsu.load_fifo.queue\[11\]\[18\] net386 net369 VGND VGND VPWR VPWR _1334_ sky130_fd_sc_hd__mux4_1
XTAP_TAPCELL_ROW_98_1305 VGND VPWR sky130_fd_sc_hd__tapvpwrvgnd_1
X_2826_ net315 net1150 net226 VGND VGND VPWR VPWR _0339_ sky130_fd_sc_hd__mux2_1
X_2757_ net277 net1220 _2027_ VGND VGND VPWR VPWR _0276_ sky130_fd_sc_hd__mux2_1
XFILLER_105_505 VPWR VGND VPWR VGND sky130_ef_sc_hd__decap_12
X_2688_ net594 net324 net232 VGND VGND VPWR VPWR _0212_ sky130_fd_sc_hd__mux2_1
X_4427_ clknet_leaf_87_clk _0484_ VGND VGND VPWR VPWR lsu.load_fifo.queue\[4\]\[3\]
+ sky130_fd_sc_hd__dfxtp_1
Xfanout413 lsu.store_fifo.r_ptr\[0\] VGND VGND VPWR VPWR net413 sky130_fd_sc_hd__clkbuf_4
Xfanout402 lsu.store_fifo.r_ptr\[3\] VGND VGND VPWR VPWR net402 sky130_fd_sc_hd__clkbuf_2
X_4358_ clknet_leaf_37_clk _0415_ _0002_ VGND VGND VPWR VPWR lsu.loader_state\[0\]
+ sky130_fd_sc_hd__dfrtp_1
Xfanout435 net436 VGND VGND VPWR VPWR net435 sky130_fd_sc_hd__buf_4
Xfanout446 net1 VGND VGND VPWR VPWR net446 sky130_fd_sc_hd__clkbuf_4
Xfanout424 net446 VGND VGND VPWR VPWR net424 sky130_fd_sc_hd__buf_4
XFILLER_48_27 VGND VGND VPWR VPWR sky130_fd_sc_hd__fill_1
XFILLER_100_243 VGND VGND VPWR VPWR sky130_fd_sc_hd__decap_8
X_3309_ net307 net63 net251 VGND VGND VPWR VPWR _0871_ sky130_fd_sc_hd__mux2_1
X_4289_ clknet_leaf_78_clk _0346_ VGND VGND VPWR VPWR lsu.load_fifo.queue\[9\]\[27\]
+ sky130_fd_sc_hd__dfxtp_1
XFILLER_100_298 VGND VGND VPWR VPWR sky130_fd_sc_hd__decap_8
XTAP_TAPCELL_ROW_57_859 VGND VPWR sky130_fd_sc_hd__tapvpwrvgnd_1
XFILLER_10_433 VPWR VGND VPWR VGND sky130_ef_sc_hd__decap_12
XFILLER_10_477 VPWR VGND VPWR VGND sky130_ef_sc_hd__decap_12
XTAP_TAPCELL_ROW_20_450 VGND VPWR sky130_fd_sc_hd__tapvpwrvgnd_1
XFILLER_77_411 VGND VGND VPWR VPWR sky130_fd_sc_hd__fill_1
XFILLER_49_113 VGND VGND VPWR VPWR sky130_fd_sc_hd__decap_6
XFILLER_89_293 VPWR VGND VPWR VGND sky130_ef_sc_hd__decap_12
XFILLER_77_444 VGND VGND VPWR VPWR sky130_fd_sc_hd__decap_4
XFILLER_77_488 VGND VGND VPWR VPWR sky130_fd_sc_hd__decap_6
XPHY_EDGE_ROW_32_Left_139 VGND VGND VPWR VPWR sky130_fd_sc_hd__decap_3
XFILLER_64_149 VGND VGND VPWR VPWR sky130_fd_sc_hd__decap_8
XTAP_TAPCELL_ROW_82_1128 VGND VPWR sky130_fd_sc_hd__tapvpwrvgnd_1
XFILLER_45_396 VGND VGND VPWR VPWR sky130_fd_sc_hd__decap_8
XFILLER_13_293 VGND VGND VPWR VPWR sky130_fd_sc_hd__decap_4
XFILLER_9_242 VGND VGND VPWR VPWR sky130_fd_sc_hd__fill_2
X_3660_ acc.byte1\[1\] acc.byte0\[1\] VGND VGND VPWR VPWR _1142_ sky130_fd_sc_hd__xnor2_2
Xclkload34 clknet_leaf_20_clk VGND VGND VPWR VPWR clkload34/X sky130_fd_sc_hd__clkbuf_8
Xclkload23 clknet_leaf_76_clk VGND VGND VPWR VPWR clkload23/Y sky130_fd_sc_hd__inv_8
X_3591_ net424 VGND VGND VPWR VPWR _0155_ sky130_fd_sc_hd__inv_2
XPHY_EDGE_ROW_41_Left_148 VGND VGND VPWR VPWR sky130_fd_sc_hd__decap_3
Xclkload12 clknet_leaf_5_clk VGND VGND VPWR VPWR clkload12/Y sky130_fd_sc_hd__clkinv_4
X_2611_ net404 _1992_ VGND VGND VPWR VPWR _1994_ sky130_fd_sc_hd__or2_1
X_2542_ net260 _1930_ VGND VGND VPWR VPWR _1944_ sky130_fd_sc_hd__nor2_1
Xclkload78 clknet_leaf_42_clk VGND VGND VPWR VPWR clkload78/Y sky130_fd_sc_hd__inv_6
Xclkload45 clknet_leaf_27_clk VGND VGND VPWR VPWR clkload45/Y sky130_fd_sc_hd__clkinvlp_4
Xclkload67 clknet_leaf_67_clk VGND VGND VPWR VPWR clkload67/Y sky130_fd_sc_hd__bufinv_16
Xclkload56 clknet_leaf_71_clk VGND VGND VPWR VPWR clkload56/Y sky130_fd_sc_hd__clkinv_8
XFILLER_55_3 VGND VGND VPWR VPWR sky130_fd_sc_hd__decap_6
XTAP_TAPCELL_ROW_93_1257 VGND VPWR sky130_fd_sc_hd__tapvpwrvgnd_1
X_2473_ net265 _1846_ net238 VGND VGND VPWR VPWR _1895_ sky130_fd_sc_hd__o21a_1
X_4212_ clknet_leaf_52_clk _0269_ VGND VGND VPWR VPWR lsu.store_fifo.queue\[5\]\[0\]
+ sky130_fd_sc_hd__dfxtp_1
XFILLER_68_433 VPWR VGND VPWR VGND sky130_ef_sc_hd__decap_12
X_4143_ clknet_leaf_87_clk _0200_ VGND VGND VPWR VPWR lsu.load_fifo.queue\[11\]\[3\]
+ sky130_fd_sc_hd__dfxtp_1
X_4074_ lsu.store_fifo.queue\[0\]\[3\] lsu.store_fifo.queue\[1\]\[3\] lsu.store_fifo.queue\[2\]\[3\]
+ lsu.store_fifo.queue\[3\]\[3\] net411 net406 VGND VGND VPWR VPWR _1508_ sky130_fd_sc_hd__mux4_1
XPHY_EDGE_ROW_50_Left_157 VGND VGND VPWR VPWR sky130_fd_sc_hd__decap_3
XFILLER_56_628 VGND VGND VPWR VPWR sky130_fd_sc_hd__fill_2
X_3025_ net807 net318 net210 VGND VGND VPWR VPWR _0531_ sky130_fd_sc_hd__mux2_1
XFILLER_91_480 VGND VGND VPWR VPWR sky130_fd_sc_hd__decap_3
XTAP_TAPCELL_ROW_54_829 VGND VPWR sky130_fd_sc_hd__tapvpwrvgnd_1
XFILLER_34_29 VGND VGND VPWR VPWR sky130_fd_sc_hd__decap_8
XTAP_TAPCELL_ROW_102_1353 VGND VPWR sky130_fd_sc_hd__tapvpwrvgnd_1
X_4976_ clknet_leaf_14_clk _1031_ _0162_ VGND VGND VPWR VPWR acc.byte3\[5\] sky130_fd_sc_hd__dfrtp_1
XFILLER_11_219 VGND VGND VPWR VPWR sky130_fd_sc_hd__decap_4
X_3927_ lsu.load_fifo.queue\[0\]\[10\] lsu.load_fifo.queue\[1\]\[10\] lsu.load_fifo.queue\[2\]\[10\]
+ lsu.load_fifo.queue\[3\]\[10\] net393 net376 VGND VGND VPWR VPWR _1378_ sky130_fd_sc_hd__mux4_1
Xclkload6 clknet_3_7__leaf_clk VGND VGND VPWR VPWR clkload6/Y sky130_fd_sc_hd__inv_6
X_3858_ lsu.load_fifo.queue\[4\]\[20\] lsu.load_fifo.queue\[5\]\[20\] lsu.load_fifo.queue\[6\]\[20\]
+ lsu.load_fifo.queue\[7\]\[20\] net384 net367 VGND VGND VPWR VPWR _1319_ sky130_fd_sc_hd__mux4_1
X_2809_ net349 net1210 net226 VGND VGND VPWR VPWR _0322_ sky130_fd_sc_hd__mux2_1
X_3789_ net1272 net255 _1260_ _1252_ VGND VGND VPWR VPWR _1033_ sky130_fd_sc_hd__o22a_1
XFILLER_3_429 VPWR VGND VPWR VGND sky130_ef_sc_hd__decap_12
Xfanout232 _2022_ VGND VGND VPWR VPWR net232 sky130_fd_sc_hd__buf_4
Xfanout221 _2036_ VGND VGND VPWR VPWR net221 sky130_fd_sc_hd__buf_2
Xfanout210 _2042_ VGND VGND VPWR VPWR net210 sky130_fd_sc_hd__buf_4
Xfanout243 net245 VGND VGND VPWR VPWR net243 sky130_fd_sc_hd__buf_2
XFILLER_86_241 VGND VGND VPWR VPWR sky130_fd_sc_hd__fill_2
Xfanout254 _1259_ VGND VGND VPWR VPWR net254 sky130_fd_sc_hd__buf_4
Xfanout265 _1719_ VGND VGND VPWR VPWR net265 sky130_fd_sc_hd__clkbuf_2
XFILLER_75_25 VGND VGND VPWR VPWR sky130_fd_sc_hd__decap_3
Xfanout276 net277 VGND VGND VPWR VPWR net276 sky130_fd_sc_hd__clkbuf_2
Xfanout287 acc.data_out\[2\] VGND VGND VPWR VPWR net287 sky130_fd_sc_hd__buf_1
Xfanout298 lsu.load_fifo.data_in\[28\] VGND VGND VPWR VPWR net298 sky130_fd_sc_hd__clkbuf_2
XFILLER_59_499 VGND VGND VPWR VPWR sky130_fd_sc_hd__fill_1
XFILLER_74_469 VGND VGND VPWR VPWR sky130_fd_sc_hd__decap_6
XFILLER_15_503 VGND VGND VPWR VPWR sky130_fd_sc_hd__fill_1
XFILLER_82_480 VPWR VGND VPWR VGND sky130_ef_sc_hd__decap_12
XFILLER_91_57 VPWR VGND VPWR VGND sky130_ef_sc_hd__decap_12
XFILLER_10_230 VPWR VGND VPWR VGND sky130_ef_sc_hd__decap_12
XFILLER_6_223 VPWR VGND VPWR VGND sky130_ef_sc_hd__decap_12
XFILLER_40_50 VGND VGND VPWR VPWR sky130_fd_sc_hd__decap_4
XFILLER_92_233 VPWR VGND VPWR VGND sky130_ef_sc_hd__decap_12
XFILLER_1_55 VGND VGND VPWR VPWR sky130_fd_sc_hd__fill_1
XFILLER_65_447 VGND VGND VPWR VPWR sky130_fd_sc_hd__fill_1
XFILLER_92_277 VPWR VGND VPWR VGND sky130_ef_sc_hd__decap_12
XFILLER_18_374 VPWR VGND VPWR VGND sky130_ef_sc_hd__decap_12
X_4830_ clknet_leaf_36_clk _0887_ _0080_ VGND VGND VPWR VPWR lsu.store_counter\[7\]
+ sky130_fd_sc_hd__dfrtp_1
X_4761_ clknet_leaf_47_clk net818 VGND VGND VPWR VPWR net146 sky130_fd_sc_hd__dfxtp_1
XFILLER_33_399 VGND VGND VPWR VPWR sky130_fd_sc_hd__fill_1
X_4692_ clknet_leaf_35_clk _0749_ _0038_ VGND VGND VPWR VPWR lsu.load_fifo.r_ptr\[0\]
+ sky130_fd_sc_hd__dfrtp_1
XTAP_TAPCELL_ROW_31_567 VGND VPWR sky130_fd_sc_hd__tapvpwrvgnd_1
X_3712_ _1139_ _1148_ VGND VGND VPWR VPWR _1194_ sky130_fd_sc_hd__xnor2_1
X_3643_ _1107_ acc.state VGND VGND VPWR VPWR _1125_ sky130_fd_sc_hd__nor2_4
X_3574_ net422 VGND VGND VPWR VPWR _0138_ sky130_fd_sc_hd__inv_2
X_2525_ lsu.current_load_addr\[18\] _1930_ VGND VGND VPWR VPWR _1931_ sky130_fd_sc_hd__and2_1
X_2456_ net1285 net252 _1881_ _1882_ VGND VGND VPWR VPWR _0801_ sky130_fd_sc_hd__a22o_1
X_2387_ lsu.store_counter\[18\] _1574_ _1583_ lsu.store_counter\[19\] VGND VGND VPWR
+ VPWR _1826_ sky130_fd_sc_hd__o22a_1
XFILLER_29_617 VGND VGND VPWR VPWR sky130_fd_sc_hd__fill_1
X_4126_ clknet_leaf_50_clk _0183_ VGND VGND VPWR VPWR lsu.store_fifo.queue\[11\]\[6\]
+ sky130_fd_sc_hd__dfxtp_1
XTAP_TAPCELL_ROW_3_259 VGND VPWR sky130_fd_sc_hd__tapvpwrvgnd_1
XFILLER_56_447 VGND VGND VPWR VPWR sky130_fd_sc_hd__decap_4
X_4057_ lsu.store_fifo.queue\[12\]\[5\] lsu.store_fifo.queue\[13\]\[5\] lsu.store_fifo.queue\[14\]\[5\]
+ lsu.store_fifo.queue\[15\]\[5\] net412 net407 VGND VGND VPWR VPWR _1493_ sky130_fd_sc_hd__mux4_1
XTAP_TAPCELL_ROW_39_656 VGND VPWR sky130_fd_sc_hd__tapvpwrvgnd_1
XTAP_TAPCELL_ROW_67_965 VGND VPWR sky130_fd_sc_hd__tapvpwrvgnd_1
X_3008_ net570 net353 net210 VGND VGND VPWR VPWR _0514_ sky130_fd_sc_hd__mux2_1
XFILLER_43_108 VGND VGND VPWR VPWR sky130_fd_sc_hd__decap_4
XFILLER_45_39 VGND VGND VPWR VPWR sky130_fd_sc_hd__fill_1
X_4959_ clknet_leaf_17_clk _1014_ _0145_ VGND VGND VPWR VPWR acc.byte1\[4\] sky130_fd_sc_hd__dfrtp_1
XFILLER_61_38 VGND VGND VPWR VPWR sky130_fd_sc_hd__fill_1
XFILLER_59_241 VGND VGND VPWR VPWR sky130_fd_sc_hd__decap_6
XFILLER_101_393 VGND VGND VPWR VPWR sky130_fd_sc_hd__decap_3
XFILLER_19_51 VGND VGND VPWR VPWR sky130_fd_sc_hd__decap_4
XFILLER_47_447 VGND VGND VPWR VPWR sky130_fd_sc_hd__fill_1
XFILLER_59_285 VGND VGND VPWR VPWR sky130_fd_sc_hd__fill_1
XFILLER_35_609 VGND VGND VPWR VPWR sky130_fd_sc_hd__fill_1
XFILLER_74_288 VGND VGND VPWR VPWR sky130_fd_sc_hd__decap_4
XPHY_EDGE_ROW_106_Left_213 VGND VGND VPWR VPWR sky130_fd_sc_hd__decap_3
XFILLER_15_388 VGND VGND VPWR VPWR sky130_fd_sc_hd__decap_4
XFILLER_11_561 VPWR VGND VPWR VGND sky130_ef_sc_hd__decap_12
XTAP_TAPCELL_ROW_90_1216 VGND VPWR sky130_fd_sc_hd__tapvpwrvgnd_1
X_2310_ lsu.store_counter\[6\] net239 _1727_ lsu.store_counter\[7\] VGND VGND VPWR
+ VPWR _1760_ sky130_fd_sc_hd__a31o_1
X_3290_ net344 net74 net250 VGND VGND VPWR VPWR _0852_ sky130_fd_sc_hd__mux2_1
X_2241_ lsu.load_counter\[2\] _1709_ net483 _1710_ VGND VGND VPWR VPWR _0907_ sky130_fd_sc_hd__a22o_1
X_2172_ lsu.load_counter\[21\] _1571_ lsu.load_counter\[22\] VGND VGND VPWR VPWR _1662_
+ sky130_fd_sc_hd__a21oi_1
XFILLER_18_3 VGND VGND VPWR VPWR sky130_fd_sc_hd__fill_2
XFILLER_38_436 VGND VGND VPWR VPWR sky130_fd_sc_hd__fill_1
XTAP_TAPCELL_ROW_0_218 VGND VPWR sky130_fd_sc_hd__tapvpwrvgnd_1
XFILLER_65_233 VGND VGND VPWR VPWR sky130_fd_sc_hd__decap_8
XTAP_TAPCELL_ROW_0_229 VGND VPWR sky130_fd_sc_hd__tapvpwrvgnd_1
XTAP_TAPCELL_ROW_36_626 VGND VPWR sky130_fd_sc_hd__tapvpwrvgnd_1
XTAP_TAPCELL_ROW_64_935 VGND VPWR sky130_fd_sc_hd__tapvpwrvgnd_1
XFILLER_61_472 VGND VGND VPWR VPWR sky130_fd_sc_hd__decap_4
X_4813_ clknet_leaf_81_clk _0870_ VGND VGND VPWR VPWR lsu.load_fifo.data_in\[23\]
+ sky130_fd_sc_hd__dfxtp_1
XFILLER_61_483 VGND VGND VPWR VPWR sky130_fd_sc_hd__fill_1
X_4744_ clknet_leaf_44_clk _0801_ _0058_ VGND VGND VPWR VPWR lsu.current_store_addr\[12\]
+ sky130_fd_sc_hd__dfrtp_1
X_4675_ clknet_leaf_29_clk _0732_ _0021_ VGND VGND VPWR VPWR lsu.current_load_addr\[5\]
+ sky130_fd_sc_hd__dfrtp_2
X_3626_ net1309 VGND VGND VPWR VPWR _1109_ sky130_fd_sc_hd__inv_2
X_3557_ net443 VGND VGND VPWR VPWR _0121_ sky130_fd_sc_hd__inv_2
XTAP_TAPCELL_ROW_8_318 VGND VPWR sky130_fd_sc_hd__tapvpwrvgnd_1
XFILLER_103_625 VGND VGND VPWR VPWR sky130_fd_sc_hd__fill_2
X_2508_ net363 _1915_ VGND VGND VPWR VPWR _1917_ sky130_fd_sc_hd__or2_1
X_3488_ net432 VGND VGND VPWR VPWR _0052_ sky130_fd_sc_hd__inv_2
X_2439_ lsu.current_store_addr\[16\] _1853_ VGND VGND VPWR VPWR _1870_ sky130_fd_sc_hd__xor2_1
XFILLER_69_561 VGND VGND VPWR VPWR sky130_fd_sc_hd__fill_1
XFILLER_17_609 VGND VGND VPWR VPWR sky130_fd_sc_hd__decap_6
X_4109_ net271 _1539_ VGND VGND VPWR VPWR _1540_ sky130_fd_sc_hd__or2_1
XFILLER_4_513 VPWR VGND VPWR VGND sky130_ef_sc_hd__decap_12
XFILLER_4_557 VPWR VGND VPWR VGND sky130_ef_sc_hd__decap_12
XTAP_TAPCELL_ROW_76_1071 VGND VPWR sky130_fd_sc_hd__tapvpwrvgnd_1
XFILLER_106_496 VGND VGND VPWR VPWR sky130_fd_sc_hd__decap_4
XFILLER_87_391 VGND VGND VPWR VPWR sky130_fd_sc_hd__fill_1
XFILLER_90_501 VPWR VGND VPWR VGND sky130_ef_sc_hd__decap_12
XFILLER_15_141 VGND VGND VPWR VPWR sky130_fd_sc_hd__fill_1
XTAP_TAPCELL_ROW_61_905 VGND VPWR sky130_fd_sc_hd__tapvpwrvgnd_1
XFILLER_62_269 VGND VGND VPWR VPWR sky130_fd_sc_hd__decap_6
XFILLER_43_483 VGND VGND VPWR VPWR sky130_fd_sc_hd__decap_8
XTAP_TAPCELL_ROW_13_375 VGND VPWR sky130_fd_sc_hd__tapvpwrvgnd_1
XTAP_TAPCELL_ROW_41_684 VGND VPWR sky130_fd_sc_hd__tapvpwrvgnd_1
X_2790_ net645 net278 _2031_ VGND VGND VPWR VPWR _0305_ sky130_fd_sc_hd__mux2_1
XFILLER_11_391 VGND VGND VPWR VPWR sky130_fd_sc_hd__fill_1
XFILLER_7_54 VGND VGND VPWR VPWR sky130_fd_sc_hd__fill_2
Xhold307 net129 VGND VGND VPWR VPWR net775 sky130_fd_sc_hd__dlygate4sd3_1
X_4460_ clknet_leaf_18_clk _0517_ VGND VGND VPWR VPWR lsu.load_fifo.queue\[3\]\[4\]
+ sky130_fd_sc_hd__dfxtp_1
Xhold329 lsu.load_fifo.queue\[4\]\[6\] VGND VGND VPWR VPWR net797 sky130_fd_sc_hd__dlygate4sd3_1
X_3411_ net733 net301 net199 VGND VGND VPWR VPWR _1061_ sky130_fd_sc_hd__mux2_1
X_4391_ clknet_leaf_79_clk _0448_ VGND VGND VPWR VPWR lsu.load_fifo.queue\[6\]\[31\]
+ sky130_fd_sc_hd__dfxtp_1
Xhold318 lsu.load_fifo.queue\[0\]\[0\] VGND VGND VPWR VPWR net786 sky130_fd_sc_hd__dlygate4sd3_1
X_3342_ net1038 net307 net176 VGND VGND VPWR VPWR _0952_ sky130_fd_sc_hd__mux2_1
XFILLER_97_111 VGND VGND VPWR VPWR sky130_fd_sc_hd__fill_1
X_3273_ _2024_ _2029_ VGND VGND VPWR VPWR _2053_ sky130_fd_sc_hd__nor2_4
X_2224_ _1103_ _1670_ VGND VGND VPWR VPWR _1700_ sky130_fd_sc_hd__and2_1
X_5012_ clknet_leaf_63_clk _1067_ VGND VGND VPWR VPWR lsu.store_fifo.queue\[13\]\[1\]
+ sky130_fd_sc_hd__dfxtp_1
X_2155_ _1631_ _1634_ _1644_ _1628_ VGND VGND VPWR VPWR _1645_ sky130_fd_sc_hd__o31a_1
XFILLER_66_531 VGND VGND VPWR VPWR sky130_fd_sc_hd__fill_1
XTAP_TAPCELL_ROW_49_773 VGND VPWR sky130_fd_sc_hd__tapvpwrvgnd_1
X_2086_ net9 _1564_ VGND VGND VPWR VPWR _1576_ sky130_fd_sc_hd__xnor2_2
XFILLER_26_439 VGND VGND VPWR VPWR sky130_fd_sc_hd__fill_1
XFILLER_22_601 VPWR VGND VPWR VGND sky130_ef_sc_hd__decap_12
XFILLER_21_111 VGND VGND VPWR VPWR sky130_fd_sc_hd__fill_1
X_2988_ net763 net325 net192 VGND VGND VPWR VPWR _0496_ sky130_fd_sc_hd__mux2_1
X_4727_ clknet_leaf_38_clk net800 VGND VGND VPWR VPWR net113 sky130_fd_sc_hd__dfxtp_1
X_4658_ clknet_leaf_61_clk _0715_ _0014_ VGND VGND VPWR VPWR lsu.store_fifo.r_ptr\[2\]
+ sky130_fd_sc_hd__dfrtp_1
Xinput90 store_base_addr[19] VGND VGND VPWR VPWR net90 sky130_fd_sc_hd__clkbuf_1
Xhold830 lsu.load_counter\[5\] VGND VGND VPWR VPWR net1298 sky130_fd_sc_hd__dlygate4sd3_1
X_3609_ net430 VGND VGND VPWR VPWR _0173_ sky130_fd_sc_hd__inv_2
XFILLER_1_505 VPWR VGND VPWR VGND sky130_ef_sc_hd__decap_12
X_4589_ clknet_leaf_6_clk _0646_ VGND VGND VPWR VPWR lsu.load_fifo.queue\[8\]\[5\]
+ sky130_fd_sc_hd__dfxtp_1
Xhold841 lsu.current_store_addr\[5\] VGND VGND VPWR VPWR net1309 sky130_fd_sc_hd__dlygate4sd3_1
XFILLER_67_26 VPWR VGND VPWR VGND sky130_ef_sc_hd__decap_12
XFILLER_72_501 VPWR VGND VPWR VGND sky130_ef_sc_hd__decap_12
XFILLER_17_417 VPWR VGND VPWR VGND sky130_ef_sc_hd__decap_12
XFILLER_72_589 VGND VGND VPWR VPWR sky130_fd_sc_hd__decap_4
XFILLER_25_461 VGND VGND VPWR VPWR sky130_fd_sc_hd__fill_1
XPHY_EDGE_ROW_11_Right_11 VGND VGND VPWR VPWR sky130_fd_sc_hd__decap_3
Xlsu_wrapper_448 VGND VGND VPWR VPWR lsu_wrapper_448/HI store_data[11] sky130_fd_sc_hd__conb_1
XFILLER_8_137 VGND VGND VPWR VPWR sky130_fd_sc_hd__decap_3
Xlsu_wrapper_459 VGND VGND VPWR VPWR lsu_wrapper_459/HI store_data[22] sky130_fd_sc_hd__conb_1
XTAP_TAPCELL_ROW_10_345 VGND VPWR sky130_fd_sc_hd__tapvpwrvgnd_1
XFILLER_99_409 VGND VGND VPWR VPWR sky130_fd_sc_hd__fill_2
XFILLER_4_365 VPWR VGND VPWR VGND sky130_ef_sc_hd__decap_12
XFILLER_106_293 VGND VGND VPWR VPWR sky130_fd_sc_hd__decap_4
XPHY_EDGE_ROW_20_Right_20 VGND VGND VPWR VPWR sky130_fd_sc_hd__decap_3
XFILLER_67_306 VGND VGND VPWR VPWR sky130_fd_sc_hd__fill_1
XFILLER_82_309 VPWR VGND VPWR VGND sky130_ef_sc_hd__decap_12
XFILLER_48_597 VGND VGND VPWR VPWR sky130_fd_sc_hd__fill_1
XTAP_TAPCELL_ROW_18_423 VGND VPWR sky130_fd_sc_hd__tapvpwrvgnd_1
XTAP_TAPCELL_ROW_46_732 VGND VPWR sky130_fd_sc_hd__tapvpwrvgnd_1
X_3960_ _1406_ _1403_ net356 VGND VGND VPWR VPWR _1407_ sky130_fd_sc_hd__mux2_1
XFILLER_63_578 VGND VGND VPWR VPWR sky130_fd_sc_hd__fill_2
X_2911_ net1142 net342 net218 VGND VGND VPWR VPWR _0423_ sky130_fd_sc_hd__mux2_1
X_3891_ lsu.load_fifo.queue\[12\]\[15\] lsu.load_fifo.queue\[13\]\[15\] lsu.load_fifo.queue\[14\]\[15\]
+ lsu.load_fifo.queue\[15\]\[15\] net395 net378 VGND VGND VPWR VPWR _1347_ sky130_fd_sc_hd__mux4_1
X_2842_ net750 net351 net224 VGND VGND VPWR VPWR _0353_ sky130_fd_sc_hd__mux2_1
X_2773_ net290 net959 _2030_ VGND VGND VPWR VPWR _0289_ sky130_fd_sc_hd__mux2_1
X_4512_ clknet_leaf_32_clk _0569_ VGND VGND VPWR VPWR lsu.load_fifo.queue\[2\]\[24\]
+ sky130_fd_sc_hd__dfxtp_1
Xhold104 lsu.load_fifo.queue\[12\]\[10\] VGND VGND VPWR VPWR net572 sky130_fd_sc_hd__dlygate4sd3_1
Xhold115 lsu.load_fifo.queue\[6\]\[23\] VGND VGND VPWR VPWR net583 sky130_fd_sc_hd__dlygate4sd3_1
XFILLER_7_192 VGND VGND VPWR VPWR sky130_fd_sc_hd__fill_1
Xhold126 lsu.load_fifo.queue\[11\]\[15\] VGND VGND VPWR VPWR net594 sky130_fd_sc_hd__dlygate4sd3_1
Xhold148 net118 VGND VGND VPWR VPWR net616 sky130_fd_sc_hd__dlygate4sd3_1
XTAP_TAPCELL_ROW_96_1288 VGND VPWR sky130_fd_sc_hd__tapvpwrvgnd_1
Xhold159 lsu.load_fifo.queue\[10\]\[17\] VGND VGND VPWR VPWR net627 sky130_fd_sc_hd__dlygate4sd3_1
Xhold137 lsu.load_fifo.queue\[4\]\[17\] VGND VGND VPWR VPWR net605 sky130_fd_sc_hd__dlygate4sd3_1
X_4443_ clknet_leaf_8_clk _0500_ VGND VGND VPWR VPWR lsu.load_fifo.queue\[4\]\[19\]
+ sky130_fd_sc_hd__dfxtp_1
X_4374_ clknet_leaf_3_clk _0431_ VGND VGND VPWR VPWR lsu.load_fifo.queue\[6\]\[14\]
+ sky130_fd_sc_hd__dfxtp_1
X_3325_ net738 net340 net176 VGND VGND VPWR VPWR _0935_ sky130_fd_sc_hd__mux2_1
X_3256_ lsu.current_store_addr\[5\] net1208 net257 VGND VGND VPWR VPWR _0816_ sky130_fd_sc_hd__mux2_1
X_2207_ lsu.load_counter\[15\] _1689_ _1687_ VGND VGND VPWR VPWR _0920_ sky130_fd_sc_hd__o21ba_1
XFILLER_85_169 VGND VGND VPWR VPWR sky130_fd_sc_hd__decap_4
XFILLER_39_564 VGND VGND VPWR VPWR sky130_fd_sc_hd__fill_1
X_3187_ net689 net324 net204 VGND VGND VPWR VPWR _0688_ sky130_fd_sc_hd__mux2_1
X_2138_ lsu.load_counter\[7\] _1619_ _1621_ _1627_ VGND VGND VPWR VPWR _1628_ sky130_fd_sc_hd__a22o_1
X_2069_ net3 net23 _1558_ VGND VGND VPWR VPWR _1559_ sky130_fd_sc_hd__or3_1
XFILLER_81_375 VPWR VGND VPWR VGND sky130_ef_sc_hd__decap_12
XTAP_TAPCELL_ROW_105_1384 VGND VPWR sky130_fd_sc_hd__tapvpwrvgnd_1
XFILLER_22_475 VGND VGND VPWR VPWR sky130_fd_sc_hd__fill_1
XFILLER_78_25 VGND VGND VPWR VPWR sky130_fd_sc_hd__decap_3
XTAP_TAPCELL_ROW_73_1030 VGND VPWR sky130_fd_sc_hd__tapvpwrvgnd_1
Xhold660 lsu.load_fifo.queue\[13\]\[20\] VGND VGND VPWR VPWR net1128 sky130_fd_sc_hd__dlygate4sd3_1
Xhold671 lsu.load_fifo.queue\[3\]\[15\] VGND VGND VPWR VPWR net1139 sky130_fd_sc_hd__dlygate4sd3_1
Xhold693 lsu.load_fifo.queue\[3\]\[21\] VGND VGND VPWR VPWR net1161 sky130_fd_sc_hd__dlygate4sd3_1
Xhold682 lsu.load_fifo.queue\[9\]\[20\] VGND VGND VPWR VPWR net1150 sky130_fd_sc_hd__dlygate4sd3_1
XFILLER_64_309 VGND VGND VPWR VPWR sky130_fd_sc_hd__decap_6
XFILLER_45_545 VPWR VGND VPWR VGND sky130_ef_sc_hd__decap_12
XTAP_TAPCELL_ROW_43_702 VGND VPWR sky130_fd_sc_hd__tapvpwrvgnd_1
XFILLER_13_497 VGND VGND VPWR VPWR sky130_fd_sc_hd__decap_6
XTAP_TAPCELL_ROW_23_481 VGND VPWR sky130_fd_sc_hd__tapvpwrvgnd_1
XTAP_TAPCELL_ROW_51_790 VGND VPWR sky130_fd_sc_hd__tapvpwrvgnd_1
XFILLER_4_77 VGND VGND VPWR VPWR sky130_fd_sc_hd__decap_6
XFILLER_68_615 VGND VGND VPWR VPWR sky130_fd_sc_hd__fill_1
X_3110_ net842 net347 net183 VGND VGND VPWR VPWR _0613_ sky130_fd_sc_hd__mux2_1
XFILLER_67_103 VGND VGND VPWR VPWR sky130_fd_sc_hd__fill_1
X_4090_ lsu.store_fifo.queue\[12\]\[2\] lsu.store_fifo.queue\[13\]\[2\] lsu.store_fifo.queue\[14\]\[2\]
+ lsu.store_fifo.queue\[15\]\[2\] net412 net407 VGND VGND VPWR VPWR _1523_ sky130_fd_sc_hd__mux4_1
X_3041_ net735 net352 net206 VGND VGND VPWR VPWR _0546_ sky130_fd_sc_hd__mux2_1
X_4992_ clknet_leaf_4_clk _1047_ VGND VGND VPWR VPWR lsu.load_fifo.queue\[14\]\[13\]
+ sky130_fd_sc_hd__dfxtp_1
XFILLER_51_526 VGND VGND VPWR VPWR sky130_fd_sc_hd__decap_8
X_3943_ lsu.load_fifo.queue\[8\]\[8\] lsu.load_fifo.queue\[9\]\[8\] lsu.load_fifo.queue\[10\]\[8\]
+ lsu.load_fifo.queue\[11\]\[8\] net398 net378 VGND VGND VPWR VPWR _1392_ sky130_fd_sc_hd__mux4_1
X_3874_ lsu.load_fifo.queue\[12\]\[18\] lsu.load_fifo.queue\[13\]\[18\] lsu.load_fifo.queue\[14\]\[18\]
+ lsu.load_fifo.queue\[15\]\[18\] net386 net369 VGND VGND VPWR VPWR _1333_ sky130_fd_sc_hd__mux4_1
XTAP_TAPCELL_ROW_98_1306 VGND VPWR sky130_fd_sc_hd__tapvpwrvgnd_1
Xclkbuf_3_2__f_clk clknet_0_clk VGND VGND VPWR VPWR clknet_3_2__leaf_clk sky130_fd_sc_hd__clkbuf_16
X_2825_ net316 net1182 net226 VGND VGND VPWR VPWR _0338_ sky130_fd_sc_hd__mux2_1
X_2756_ net279 net1035 _2027_ VGND VGND VPWR VPWR _0275_ sky130_fd_sc_hd__mux2_1
XFILLER_105_517 VPWR VGND VPWR VGND sky130_ef_sc_hd__decap_12
X_2687_ net806 net327 net230 VGND VGND VPWR VPWR _0211_ sky130_fd_sc_hd__mux2_1
X_4426_ clknet_leaf_21_clk _0483_ VGND VGND VPWR VPWR lsu.load_fifo.queue\[4\]\[2\]
+ sky130_fd_sc_hd__dfxtp_1
Xfanout403 net405 VGND VGND VPWR VPWR net403 sky130_fd_sc_hd__buf_2
Xfanout414 net415 VGND VGND VPWR VPWR net414 sky130_fd_sc_hd__buf_4
Xfanout436 net439 VGND VGND VPWR VPWR net436 sky130_fd_sc_hd__buf_4
X_4357_ clknet_leaf_79_clk _0414_ VGND VGND VPWR VPWR lsu.load_fifo.queue\[7\]\[31\]
+ sky130_fd_sc_hd__dfxtp_1
Xfanout425 net446 VGND VGND VPWR VPWR net425 sky130_fd_sc_hd__clkbuf_4
XFILLER_98_294 VPWR VGND VPWR VGND sky130_ef_sc_hd__decap_12
X_3308_ net309 net62 net249 VGND VGND VPWR VPWR _0870_ sky130_fd_sc_hd__mux2_1
X_4288_ clknet_leaf_17_clk _0345_ VGND VGND VPWR VPWR lsu.load_fifo.queue\[9\]\[26\]
+ sky130_fd_sc_hd__dfxtp_1
X_3239_ net533 lsu.current_load_addr\[11\] net237 VGND VGND VPWR VPWR _0777_ sky130_fd_sc_hd__mux2_1
XFILLER_46_309 VPWR VGND VPWR VGND sky130_ef_sc_hd__decap_12
XFILLER_66_191 VGND VGND VPWR VPWR sky130_fd_sc_hd__decap_4
XFILLER_80_48 VPWR VGND VPWR VGND sky130_ef_sc_hd__decap_12
XFILLER_22_250 VGND VGND VPWR VPWR sky130_fd_sc_hd__fill_2
XFILLER_50_592 VGND VGND VPWR VPWR sky130_fd_sc_hd__decap_3
XFILLER_10_445 VPWR VGND VPWR VGND sky130_ef_sc_hd__decap_12
XFILLER_10_489 VPWR VGND VPWR VGND sky130_ef_sc_hd__decap_12
XTAP_TAPCELL_ROW_20_451 VGND VPWR sky130_fd_sc_hd__tapvpwrvgnd_1
XFILLER_89_57 VPWR VGND VPWR VGND sky130_ef_sc_hd__decap_12
XFILLER_96_209 VPWR VGND VPWR VGND sky130_ef_sc_hd__decap_12
Xhold490 lsu.store_fifo.queue\[15\]\[3\] VGND VGND VPWR VPWR net958 sky130_fd_sc_hd__dlygate4sd3_1
XFILLER_89_261 VPWR VGND VPWR VGND sky130_ef_sc_hd__decap_12
XFILLER_92_448 VGND VGND VPWR VPWR sky130_fd_sc_hd__fill_1
XTAP_TAPCELL_ROW_28_540 VGND VPWR sky130_fd_sc_hd__tapvpwrvgnd_1
XTAP_TAPCELL_ROW_82_1129 VGND VPWR sky130_fd_sc_hd__tapvpwrvgnd_1
XFILLER_18_589 VPWR VGND VPWR VGND sky130_ef_sc_hd__decap_12
XFILLER_33_559 VGND VGND VPWR VPWR sky130_fd_sc_hd__fill_1
XFILLER_60_334 VGND VGND VPWR VPWR sky130_fd_sc_hd__fill_1
XFILLER_13_272 VGND VGND VPWR VPWR sky130_fd_sc_hd__decap_8
Xclkload35 clknet_leaf_21_clk VGND VGND VPWR VPWR clkload35/Y sky130_fd_sc_hd__clkinv_2
X_3590_ net427 VGND VGND VPWR VPWR _0154_ sky130_fd_sc_hd__inv_2
Xclkload24 clknet_leaf_77_clk VGND VGND VPWR VPWR clkload24/Y sky130_fd_sc_hd__clkinv_4
Xclkload13 clknet_leaf_6_clk VGND VGND VPWR VPWR clkload13/Y sky130_fd_sc_hd__inv_8
X_2610_ net401 _1993_ VGND VGND VPWR VPWR _0716_ sky130_fd_sc_hd__xnor2_1
Xclkload46 clknet_leaf_28_clk VGND VGND VPWR VPWR clkload46/Y sky130_fd_sc_hd__inv_6
X_2541_ lsu.current_load_addr\[16\] lsu.current_load_addr\[15\] _1928_ lsu.current_load_addr\[17\]
+ VGND VGND VPWR VPWR _1943_ sky130_fd_sc_hd__a31o_1
Xclkload57 clknet_leaf_72_clk VGND VGND VPWR VPWR clkload57/Y sky130_fd_sc_hd__clkinv_4
Xclkload68 clknet_leaf_34_clk VGND VGND VPWR VPWR clkload68/Y sky130_fd_sc_hd__clkinvlp_4
Xclkload79 clknet_leaf_43_clk VGND VGND VPWR VPWR clkload79/Y sky130_fd_sc_hd__inv_6
XTAP_TAPCELL_ROW_93_1258 VGND VPWR sky130_fd_sc_hd__tapvpwrvgnd_1
X_2472_ net99 net265 VGND VGND VPWR VPWR _1894_ sky130_fd_sc_hd__nand2_1
X_4211_ clknet_leaf_71_clk _0268_ VGND VGND VPWR VPWR lsu.store_fifo.queue\[6\]\[9\]
+ sky130_fd_sc_hd__dfxtp_1
XFILLER_48_3 VGND VGND VPWR VPWR sky130_fd_sc_hd__fill_2
X_4142_ clknet_leaf_21_clk _0199_ VGND VGND VPWR VPWR lsu.load_fifo.queue\[11\]\[2\]
+ sky130_fd_sc_hd__dfxtp_1
XFILLER_68_445 VGND VGND VPWR VPWR sky130_fd_sc_hd__decap_6
XFILLER_83_415 VPWR VGND VPWR VGND sky130_ef_sc_hd__decap_12
X_4073_ net1243 net247 _1507_ VGND VGND VPWR VPWR _0996_ sky130_fd_sc_hd__o21a_1
X_3024_ net1090 net321 net211 VGND VGND VPWR VPWR _0530_ sky130_fd_sc_hd__mux2_1
XTAP_TAPCELL_ROW_54_819 VGND VPWR sky130_fd_sc_hd__tapvpwrvgnd_1
XFILLER_70_109 VGND VGND VPWR VPWR sky130_fd_sc_hd__decap_4
XFILLER_63_150 VGND VGND VPWR VPWR sky130_fd_sc_hd__fill_1
X_4975_ clknet_leaf_13_clk _1030_ _0161_ VGND VGND VPWR VPWR acc.byte3\[4\] sky130_fd_sc_hd__dfrtp_1
XTAP_TAPCELL_ROW_102_1354 VGND VPWR sky130_fd_sc_hd__tapvpwrvgnd_1
X_3926_ lsu.load_fifo.queue\[4\]\[10\] lsu.load_fifo.queue\[5\]\[10\] lsu.load_fifo.queue\[6\]\[10\]
+ lsu.load_fifo.queue\[7\]\[10\] net393 net376 VGND VGND VPWR VPWR _1377_ sky130_fd_sc_hd__mux4_1
XFILLER_32_592 VGND VGND VPWR VPWR sky130_fd_sc_hd__decap_6
X_3857_ net1265 _1318_ net254 VGND VGND VPWR VPWR _1023_ sky130_fd_sc_hd__mux2_1
Xclkload7 clknet_leaf_0_clk VGND VGND VPWR VPWR clkload7/Y sky130_fd_sc_hd__inv_8
X_2808_ net350 net997 net228 VGND VGND VPWR VPWR _0321_ sky130_fd_sc_hd__mux2_1
X_3788_ net357 _1248_ net255 VGND VGND VPWR VPWR _1260_ sky130_fd_sc_hd__a21bo_1
X_2739_ net619 net290 _2026_ VGND VGND VPWR VPWR _0259_ sky130_fd_sc_hd__mux2_1
Xfanout200 _2057_ VGND VGND VPWR VPWR net200 sky130_fd_sc_hd__buf_4
XTAP_TAPCELL_ROW_70_1000 VGND VPWR sky130_fd_sc_hd__tapvpwrvgnd_1
X_4409_ clknet_leaf_80_clk _0466_ VGND VGND VPWR VPWR lsu.load_fifo.queue\[5\]\[17\]
+ sky130_fd_sc_hd__dfxtp_1
Xfanout211 _2042_ VGND VGND VPWR VPWR net211 sky130_fd_sc_hd__buf_2
Xfanout222 _2035_ VGND VGND VPWR VPWR net222 sky130_fd_sc_hd__buf_4
Xfanout244 net245 VGND VGND VPWR VPWR net244 sky130_fd_sc_hd__buf_2
Xfanout233 _2022_ VGND VGND VPWR VPWR net233 sky130_fd_sc_hd__buf_2
Xfanout255 net256 VGND VGND VPWR VPWR net255 sky130_fd_sc_hd__clkbuf_4
XFILLER_59_445 VGND VGND VPWR VPWR sky130_fd_sc_hd__decap_3
Xfanout266 _1719_ VGND VGND VPWR VPWR net266 sky130_fd_sc_hd__buf_2
XFILLER_75_37 VGND VGND VPWR VPWR sky130_fd_sc_hd__fill_1
Xfanout277 acc.data_out\[7\] VGND VGND VPWR VPWR net277 sky130_fd_sc_hd__buf_2
Xfanout288 acc.data_out\[1\] VGND VGND VPWR VPWR net288 sky130_fd_sc_hd__buf_2
Xfanout299 lsu.load_fifo.data_in\[28\] VGND VGND VPWR VPWR net299 sky130_fd_sc_hd__buf_1
XFILLER_42_301 VGND VGND VPWR VPWR sky130_fd_sc_hd__fill_2
XFILLER_54_150 VGND VGND VPWR VPWR sky130_fd_sc_hd__decap_8
XFILLER_82_492 VPWR VGND VPWR VGND sky130_ef_sc_hd__decap_12
XFILLER_15_559 VGND VGND VPWR VPWR sky130_fd_sc_hd__fill_1
XTAP_TAPCELL_ROW_25_510 VGND VPWR sky130_fd_sc_hd__tapvpwrvgnd_1
XFILLER_91_69 VPWR VGND VPWR VGND sky130_ef_sc_hd__decap_12
XFILLER_10_253 VGND VGND VPWR VPWR sky130_fd_sc_hd__decap_4
XFILLER_10_242 VGND VGND VPWR VPWR sky130_fd_sc_hd__decap_8
XFILLER_6_235 VGND VGND VPWR VPWR sky130_fd_sc_hd__decap_8
XFILLER_77_242 VGND VGND VPWR VPWR sky130_fd_sc_hd__decap_4
XTAP_TAPCELL_ROW_5_290 VGND VPWR sky130_fd_sc_hd__tapvpwrvgnd_1
XFILLER_37_117 VGND VGND VPWR VPWR sky130_fd_sc_hd__fill_1
XFILLER_92_245 VGND VGND VPWR VPWR sky130_fd_sc_hd__decap_6
XFILLER_65_459 VGND VGND VPWR VPWR sky130_fd_sc_hd__decap_8
XFILLER_92_289 VPWR VGND VPWR VGND sky130_ef_sc_hd__decap_12
XFILLER_18_386 VPWR VGND VPWR VGND sky130_ef_sc_hd__decap_12
XFILLER_60_120 VGND VGND VPWR VPWR sky130_fd_sc_hd__fill_1
X_4760_ clknet_leaf_43_clk _0817_ VGND VGND VPWR VPWR net145 sky130_fd_sc_hd__dfxtp_1
XFILLER_14_581 VGND VGND VPWR VPWR sky130_fd_sc_hd__decap_6
XFILLER_60_197 VGND VGND VPWR VPWR sky130_fd_sc_hd__decap_8
X_4691_ clknet_leaf_39_clk _0748_ _0037_ VGND VGND VPWR VPWR lsu.current_load_addr\[21\]
+ sky130_fd_sc_hd__dfrtp_1
XTAP_TAPCELL_ROW_31_568 VGND VPWR sky130_fd_sc_hd__tapvpwrvgnd_1
X_3711_ _1191_ _1192_ VGND VGND VPWR VPWR _1193_ sky130_fd_sc_hd__nand2_1
X_3642_ net22 VGND VGND VPWR VPWR _1124_ sky130_fd_sc_hd__inv_2
XPHY_EDGE_ROW_49_Right_49 VGND VGND VPWR VPWR sky130_fd_sc_hd__decap_3
X_3573_ net423 VGND VGND VPWR VPWR _0137_ sky130_fd_sc_hd__inv_2
X_2524_ lsu.current_load_addr\[17\] lsu.current_load_addr\[16\] _1929_ VGND VGND VPWR
+ VPWR _1930_ sky130_fd_sc_hd__and3_1
X_2455_ net83 net268 net242 VGND VGND VPWR VPWR _1882_ sky130_fd_sc_hd__o21a_1
X_2386_ _1796_ _1824_ _1822_ _1819_ VGND VGND VPWR VPWR _1825_ sky130_fd_sc_hd__a211o_1
XFILLER_68_220 VGND VGND VPWR VPWR sky130_fd_sc_hd__fill_2
XFILLER_96_562 VGND VGND VPWR VPWR sky130_fd_sc_hd__fill_1
XFILLER_96_551 VGND VGND VPWR VPWR sky130_fd_sc_hd__fill_1
XFILLER_68_253 VGND VGND VPWR VPWR sky130_fd_sc_hd__decap_6
X_4125_ clknet_leaf_65_clk _0182_ VGND VGND VPWR VPWR lsu.store_fifo.queue\[11\]\[5\]
+ sky130_fd_sc_hd__dfxtp_1
XFILLER_96_595 VGND VGND VPWR VPWR sky130_fd_sc_hd__fill_1
XFILLER_56_415 VGND VGND VPWR VPWR sky130_fd_sc_hd__decap_4
XFILLER_83_234 VGND VGND VPWR VPWR sky130_fd_sc_hd__decap_6
X_4056_ lsu.store_fifo.queue\[4\]\[5\] lsu.store_fifo.queue\[5\]\[5\] lsu.store_fifo.queue\[6\]\[5\]
+ lsu.store_fifo.queue\[7\]\[5\] net411 net406 VGND VGND VPWR VPWR _1492_ sky130_fd_sc_hd__mux4_1
XTAP_TAPCELL_ROW_39_657 VGND VPWR sky130_fd_sc_hd__tapvpwrvgnd_1
XPHY_EDGE_ROW_58_Right_58 VGND VGND VPWR VPWR sky130_fd_sc_hd__decap_3
XTAP_TAPCELL_ROW_67_966 VGND VPWR sky130_fd_sc_hd__tapvpwrvgnd_1
X_3007_ net581 net354 net213 VGND VGND VPWR VPWR _0513_ sky130_fd_sc_hd__mux2_1
XFILLER_64_470 VGND VGND VPWR VPWR sky130_fd_sc_hd__fill_1
XFILLER_101_57 VPWR VGND VPWR VGND sky130_ef_sc_hd__decap_12
X_4958_ clknet_leaf_8_clk _1013_ _0144_ VGND VGND VPWR VPWR acc.byte1\[3\] sky130_fd_sc_hd__dfrtp_1
X_4889_ clknet_leaf_31_clk _0944_ VGND VGND VPWR VPWR lsu.load_fifo.queue\[12\]\[16\]
+ sky130_fd_sc_hd__dfxtp_1
X_3909_ _1362_ _1361_ net362 VGND VGND VPWR VPWR _1363_ sky130_fd_sc_hd__mux2_1
XPHY_EDGE_ROW_67_Right_67 VGND VGND VPWR VPWR sky130_fd_sc_hd__decap_3
XFILLER_10_54 VGND VGND VPWR VPWR sky130_fd_sc_hd__fill_2
XPHY_EDGE_ROW_76_Right_76 VGND VGND VPWR VPWR sky130_fd_sc_hd__decap_3
XFILLER_59_275 VGND VGND VPWR VPWR sky130_fd_sc_hd__decap_4
XFILLER_43_610 VGND VGND VPWR VPWR sky130_fd_sc_hd__fill_2
XFILLER_15_345 VGND VGND VPWR VPWR sky130_fd_sc_hd__fill_1
XFILLER_42_175 VGND VGND VPWR VPWR sky130_fd_sc_hd__decap_4
XFILLER_42_186 VGND VGND VPWR VPWR sky130_fd_sc_hd__decap_3
XPHY_EDGE_ROW_85_Right_85 VGND VGND VPWR VPWR sky130_fd_sc_hd__decap_3
XFILLER_11_573 VPWR VGND VPWR VGND sky130_ef_sc_hd__decap_12
XTAP_TAPCELL_ROW_90_1217 VGND VPWR sky130_fd_sc_hd__tapvpwrvgnd_1
XFILLER_97_337 VPWR VGND VPWR VGND sky130_ef_sc_hd__decap_12
X_2240_ lsu.load_counter\[2\] lsu.load_counter\[1\] lsu.load_counter\[0\] VGND VGND
+ VPWR VPWR _1710_ sky130_fd_sc_hd__and3b_1
XPHY_EDGE_ROW_94_Right_94 VGND VGND VPWR VPWR sky130_fd_sc_hd__decap_3
X_2171_ _1585_ _1653_ _1659_ VGND VGND VPWR VPWR _1661_ sky130_fd_sc_hd__a21o_1
XFILLER_93_521 VGND VGND VPWR VPWR sky130_fd_sc_hd__fill_2
XFILLER_38_415 VGND VGND VPWR VPWR sky130_fd_sc_hd__decap_4
XTAP_TAPCELL_ROW_0_219 VGND VPWR sky130_fd_sc_hd__tapvpwrvgnd_1
XTAP_TAPCELL_ROW_36_627 VGND VPWR sky130_fd_sc_hd__tapvpwrvgnd_1
XTAP_TAPCELL_ROW_64_936 VGND VPWR sky130_fd_sc_hd__tapvpwrvgnd_1
X_4812_ clknet_leaf_68_clk _0869_ VGND VGND VPWR VPWR lsu.load_fifo.data_in\[22\]
+ sky130_fd_sc_hd__dfxtp_1
XFILLER_21_337 VGND VGND VPWR VPWR sky130_fd_sc_hd__fill_2
XFILLER_21_359 VGND VGND VPWR VPWR sky130_fd_sc_hd__decap_4
X_4743_ clknet_leaf_62_clk _0800_ _0057_ VGND VGND VPWR VPWR lsu.current_store_addr\[11\]
+ sky130_fd_sc_hd__dfrtp_1
X_4674_ clknet_leaf_29_clk _0731_ _0020_ VGND VGND VPWR VPWR lsu.current_load_addr\[4\]
+ sky130_fd_sc_hd__dfrtp_1
X_3625_ net1276 VGND VGND VPWR VPWR _1108_ sky130_fd_sc_hd__inv_2
X_3556_ net443 VGND VGND VPWR VPWR _0120_ sky130_fd_sc_hd__inv_2
XFILLER_103_615 VGND VGND VPWR VPWR sky130_fd_sc_hd__fill_1
XFILLER_88_315 VGND VGND VPWR VPWR sky130_fd_sc_hd__fill_1
XTAP_TAPCELL_ROW_8_319 VGND VPWR sky130_fd_sc_hd__tapvpwrvgnd_1
X_2507_ net358 _1916_ VGND VGND VPWR VPWR _0752_ sky130_fd_sc_hd__xnor2_1
X_3487_ net432 VGND VGND VPWR VPWR _0051_ sky130_fd_sc_hd__inv_2
XFILLER_102_169 VGND VGND VPWR VPWR sky130_fd_sc_hd__decap_4
X_2438_ net1282 _1724_ _1868_ _1869_ VGND VGND VPWR VPWR _0806_ sky130_fd_sc_hd__a22o_1
X_2369_ _1805_ _1806_ _1807_ _1804_ VGND VGND VPWR VPWR _1808_ sky130_fd_sc_hd__and4b_1
XFILLER_56_201 VGND VGND VPWR VPWR sky130_fd_sc_hd__decap_4
XFILLER_56_39 VGND VGND VPWR VPWR sky130_fd_sc_hd__fill_2
XFILLER_56_223 VGND VGND VPWR VPWR sky130_fd_sc_hd__fill_1
X_4108_ lsu.store_fifo.queue\[8\]\[0\] lsu.store_fifo.queue\[9\]\[0\] lsu.store_fifo.queue\[10\]\[0\]
+ lsu.store_fifo.queue\[11\]\[0\] net415 net410 VGND VGND VPWR VPWR _1539_ sky130_fd_sc_hd__mux4_1
X_4039_ net246 _1476_ VGND VGND VPWR VPWR _1477_ sky130_fd_sc_hd__nand2_1
XFILLER_44_418 VGND VGND VPWR VPWR sky130_fd_sc_hd__fill_2
XFILLER_56_278 VGND VGND VPWR VPWR sky130_fd_sc_hd__decap_4
XFILLER_25_621 VGND VGND VPWR VPWR sky130_fd_sc_hd__decap_8
XFILLER_24_186 VGND VGND VPWR VPWR sky130_fd_sc_hd__fill_1
XFILLER_4_525 VGND VGND VPWR VPWR sky130_fd_sc_hd__decap_6
XTAP_TAPCELL_ROW_76_1061 VGND VPWR sky130_fd_sc_hd__tapvpwrvgnd_1
XFILLER_4_569 VPWR VGND VPWR VGND sky130_ef_sc_hd__decap_12
XFILLER_97_57 VPWR VGND VPWR VGND sky130_ef_sc_hd__decap_12
XFILLER_94_307 VGND VGND VPWR VPWR sky130_fd_sc_hd__fill_1
XFILLER_47_223 VGND VGND VPWR VPWR sky130_fd_sc_hd__fill_1
XFILLER_47_245 VGND VGND VPWR VPWR sky130_fd_sc_hd__fill_1
XFILLER_90_513 VGND VGND VPWR VPWR sky130_fd_sc_hd__decap_6
XFILLER_90_579 VGND VGND VPWR VPWR sky130_fd_sc_hd__decap_8
XTAP_TAPCELL_ROW_87_1190 VGND VPWR sky130_fd_sc_hd__tapvpwrvgnd_1
XTAP_TAPCELL_ROW_61_906 VGND VPWR sky130_fd_sc_hd__tapvpwrvgnd_1
XTAP_TAPCELL_ROW_13_376 VGND VPWR sky130_fd_sc_hd__tapvpwrvgnd_1
XTAP_TAPCELL_ROW_41_685 VGND VPWR sky130_fd_sc_hd__tapvpwrvgnd_1
Xhold308 _0822_ VGND VGND VPWR VPWR net776 sky130_fd_sc_hd__dlygate4sd3_1
Xhold319 lsu.load_fifo.queue\[5\]\[1\] VGND VGND VPWR VPWR net787 sky130_fd_sc_hd__dlygate4sd3_1
X_3410_ net1064 net303 net200 VGND VGND VPWR VPWR _1060_ sky130_fd_sc_hd__mux2_1
X_4390_ clknet_leaf_13_clk _0447_ VGND VGND VPWR VPWR lsu.load_fifo.queue\[6\]\[30\]
+ sky130_fd_sc_hd__dfxtp_1
X_3341_ net722 net309 net174 VGND VGND VPWR VPWR _0951_ sky130_fd_sc_hd__mux2_1
XFILLER_97_167 VGND VGND VPWR VPWR sky130_fd_sc_hd__fill_1
X_3272_ lsu.current_store_addr\[21\] net926 net258 VGND VGND VPWR VPWR _0832_ sky130_fd_sc_hd__mux2_1
XFILLER_30_3 VGND VGND VPWR VPWR sky130_fd_sc_hd__decap_8
X_2223_ net168 net163 _1670_ net263 net245 VGND VGND VPWR VPWR _1699_ sky130_fd_sc_hd__o221a_1
X_5011_ clknet_leaf_48_clk _1066_ VGND VGND VPWR VPWR lsu.store_fifo.queue\[13\]\[0\]
+ sky130_fd_sc_hd__dfxtp_1
X_2154_ _1636_ _1643_ VGND VGND VPWR VPWR _1644_ sky130_fd_sc_hd__and2_1
XFILLER_93_373 VGND VGND VPWR VPWR sky130_fd_sc_hd__decap_4
XFILLER_81_502 VGND VGND VPWR VPWR sky130_fd_sc_hd__fill_2
XTAP_TAPCELL_ROW_49_774 VGND VPWR sky130_fd_sc_hd__tapvpwrvgnd_1
X_2085_ _1574_ lsu.load_counter\[18\] VGND VGND VPWR VPWR _1575_ sky130_fd_sc_hd__xnor2_2
XFILLER_22_613 VPWR VGND VPWR VGND sky130_ef_sc_hd__decap_12
XFILLER_21_123 VPWR VGND VPWR VGND sky130_ef_sc_hd__decap_12
XFILLER_61_281 VPWR VGND VPWR VGND sky130_ef_sc_hd__decap_12
X_2987_ net783 net326 net189 VGND VGND VPWR VPWR _0495_ sky130_fd_sc_hd__mux2_1
X_4726_ clknet_leaf_25_clk _0783_ VGND VGND VPWR VPWR net112 sky130_fd_sc_hd__dfxtp_1
X_4657_ clknet_leaf_49_clk _0714_ _0013_ VGND VGND VPWR VPWR lsu.store_fifo.r_ptr\[1\]
+ sky130_fd_sc_hd__dfrtp_1
Xinput80 store_base_addr[0] VGND VGND VPWR VPWR net80 sky130_fd_sc_hd__buf_1
Xinput91 store_base_addr[1] VGND VGND VPWR VPWR net91 sky130_fd_sc_hd__buf_1
Xhold820 lsu.store_counter\[1\] VGND VGND VPWR VPWR net1288 sky130_fd_sc_hd__dlygate4sd3_1
X_3608_ net424 VGND VGND VPWR VPWR _0172_ sky130_fd_sc_hd__inv_2
Xhold831 lsu.current_store_addr\[20\] VGND VGND VPWR VPWR net1299 sky130_fd_sc_hd__dlygate4sd3_1
XFILLER_1_517 VPWR VGND VPWR VGND sky130_ef_sc_hd__decap_12
Xhold842 lsu.load_fifo.data_in\[22\] VGND VGND VPWR VPWR net1310 sky130_fd_sc_hd__dlygate4sd3_1
X_4588_ clknet_leaf_17_clk _0645_ VGND VGND VPWR VPWR lsu.load_fifo.queue\[8\]\[4\]
+ sky130_fd_sc_hd__dfxtp_1
X_3539_ net438 VGND VGND VPWR VPWR _0103_ sky130_fd_sc_hd__inv_2
XFILLER_88_156 VGND VGND VPWR VPWR sky130_fd_sc_hd__decap_3
XFILLER_57_521 VGND VGND VPWR VPWR sky130_fd_sc_hd__fill_2
XFILLER_72_513 VPWR VGND VPWR VGND sky130_ef_sc_hd__decap_12
XFILLER_17_429 VPWR VGND VPWR VGND sky130_ef_sc_hd__decap_12
XFILLER_44_259 VGND VGND VPWR VPWR sky130_fd_sc_hd__fill_1
XFILLER_12_101 VGND VGND VPWR VPWR sky130_fd_sc_hd__fill_1
XFILLER_52_270 VGND VGND VPWR VPWR sky130_fd_sc_hd__fill_1
XFILLER_9_617 VPWR VGND VPWR VGND sky130_ef_sc_hd__decap_12
XFILLER_12_178 VGND VGND VPWR VPWR sky130_fd_sc_hd__fill_1
Xlsu_wrapper_449 VGND VGND VPWR VPWR lsu_wrapper_449/HI store_data[12] sky130_fd_sc_hd__conb_1
XTAP_TAPCELL_ROW_10_335 VGND VPWR sky130_fd_sc_hd__tapvpwrvgnd_1
XFILLER_106_272 VGND VGND VPWR VPWR sky130_fd_sc_hd__decap_4
XFILLER_4_377 VPWR VGND VPWR VGND sky130_ef_sc_hd__decap_12
XFILLER_0_561 VPWR VGND VPWR VGND sky130_ef_sc_hd__decap_12
XFILLER_0_594 VGND VGND VPWR VPWR sky130_fd_sc_hd__decap_4
XTAP_TAPCELL_ROW_18_424 VGND VPWR sky130_fd_sc_hd__tapvpwrvgnd_1
XTAP_TAPCELL_ROW_46_733 VGND VPWR sky130_fd_sc_hd__tapvpwrvgnd_1
XFILLER_90_365 VPWR VGND VPWR VGND sky130_ef_sc_hd__decap_12
X_2910_ net975 net344 net220 VGND VGND VPWR VPWR _0422_ sky130_fd_sc_hd__mux2_1
X_3890_ lsu.load_fifo.queue\[8\]\[15\] lsu.load_fifo.queue\[9\]\[15\] lsu.load_fifo.queue\[10\]\[15\]
+ lsu.load_fifo.queue\[11\]\[15\] net395 net378 VGND VGND VPWR VPWR _1346_ sky130_fd_sc_hd__mux4_1
X_2841_ net1056 net352 net223 VGND VGND VPWR VPWR _0352_ sky130_fd_sc_hd__mux2_1
XFILLER_78_3 VGND VGND VPWR VPWR sky130_fd_sc_hd__decap_6
X_2772_ _2013_ _2029_ VGND VGND VPWR VPWR _2030_ sky130_fd_sc_hd__or2_4
X_4511_ clknet_leaf_81_clk _0568_ VGND VGND VPWR VPWR lsu.load_fifo.queue\[2\]\[23\]
+ sky130_fd_sc_hd__dfxtp_1
Xhold116 lsu.load_fifo.queue\[10\]\[27\] VGND VGND VPWR VPWR net584 sky130_fd_sc_hd__dlygate4sd3_1
X_4442_ clknet_leaf_1_clk _0499_ VGND VGND VPWR VPWR lsu.load_fifo.queue\[4\]\[18\]
+ sky130_fd_sc_hd__dfxtp_1
Xhold105 lsu.load_fifo.queue\[0\]\[12\] VGND VGND VPWR VPWR net573 sky130_fd_sc_hd__dlygate4sd3_1
XTAP_TAPCELL_ROW_96_1289 VGND VPWR sky130_fd_sc_hd__tapvpwrvgnd_1
Xhold127 lsu.load_fifo.queue\[3\]\[23\] VGND VGND VPWR VPWR net595 sky130_fd_sc_hd__dlygate4sd3_1
Xhold138 lsu.store_fifo.queue\[12\]\[5\] VGND VGND VPWR VPWR net606 sky130_fd_sc_hd__dlygate4sd3_1
Xhold149 lsu.store_fifo.queue\[7\]\[6\] VGND VGND VPWR VPWR net617 sky130_fd_sc_hd__dlygate4sd3_1
X_4373_ clknet_leaf_4_clk _0430_ VGND VGND VPWR VPWR lsu.load_fifo.queue\[6\]\[13\]
+ sky130_fd_sc_hd__dfxtp_1
X_3324_ net845 net342 net173 VGND VGND VPWR VPWR _0934_ sky130_fd_sc_hd__mux2_1
X_3255_ net1314 net1187 net257 VGND VGND VPWR VPWR _0815_ sky130_fd_sc_hd__mux2_1
X_2206_ net167 net164 _1673_ net244 lsu.load_counter\[14\] VGND VGND VPWR VPWR _1689_
+ sky130_fd_sc_hd__o2111a_1
X_3186_ net705 net326 net202 VGND VGND VPWR VPWR _0687_ sky130_fd_sc_hd__mux2_1
X_2137_ _1626_ _1625_ VGND VGND VPWR VPWR _1627_ sky130_fd_sc_hd__nand2b_1
XFILLER_93_181 VPWR VGND VPWR VGND sky130_ef_sc_hd__decap_12
X_2068_ net22 net18 _1555_ _1554_ VGND VGND VPWR VPWR _1558_ sky130_fd_sc_hd__or4_4
XFILLER_81_387 VGND VGND VPWR VPWR sky130_fd_sc_hd__decap_4
XTAP_TAPCELL_ROW_105_1385 VGND VPWR sky130_fd_sc_hd__tapvpwrvgnd_1
XFILLER_34_281 VGND VGND VPWR VPWR sky130_fd_sc_hd__decap_6
X_4709_ clknet_leaf_25_clk _0766_ VGND VGND VPWR VPWR net104 sky130_fd_sc_hd__dfxtp_1
XTAP_TAPCELL_ROW_73_1031 VGND VPWR sky130_fd_sc_hd__tapvpwrvgnd_1
Xhold672 lsu.load_fifo.queue\[1\]\[9\] VGND VGND VPWR VPWR net1140 sky130_fd_sc_hd__dlygate4sd3_1
XFILLER_1_314 VGND VGND VPWR VPWR sky130_fd_sc_hd__decap_3
Xhold661 lsu.load_fifo.queue\[8\]\[14\] VGND VGND VPWR VPWR net1129 sky130_fd_sc_hd__dlygate4sd3_1
Xhold650 lsu.load_fifo.queue\[9\]\[31\] VGND VGND VPWR VPWR net1118 sky130_fd_sc_hd__dlygate4sd3_1
Xhold694 lsu.load_fifo.queue\[9\]\[16\] VGND VGND VPWR VPWR net1162 sky130_fd_sc_hd__dlygate4sd3_1
Xhold683 lsu.store_fifo.queue\[9\]\[4\] VGND VGND VPWR VPWR net1151 sky130_fd_sc_hd__dlygate4sd3_1
XFILLER_49_329 VGND VGND VPWR VPWR sky130_fd_sc_hd__decap_6
XFILLER_76_137 VGND VGND VPWR VPWR sky130_fd_sc_hd__decap_3
XFILLER_72_321 VGND VGND VPWR VPWR sky130_fd_sc_hd__fill_1
XFILLER_45_513 VGND VGND VPWR VPWR sky130_fd_sc_hd__decap_3
XFILLER_45_557 VGND VGND VPWR VPWR sky130_fd_sc_hd__decap_3
XTAP_TAPCELL_ROW_43_703 VGND VPWR sky130_fd_sc_hd__tapvpwrvgnd_1
XFILLER_53_590 VGND VGND VPWR VPWR sky130_fd_sc_hd__decap_8
XFILLER_9_447 VGND VGND VPWR VPWR sky130_fd_sc_hd__fill_1
XTAP_TAPCELL_ROW_23_482 VGND VPWR sky130_fd_sc_hd__tapvpwrvgnd_1
XTAP_TAPCELL_ROW_51_791 VGND VPWR sky130_fd_sc_hd__tapvpwrvgnd_1
XFILLER_4_141 VGND VGND VPWR VPWR sky130_fd_sc_hd__fill_1
XFILLER_99_229 VGND VGND VPWR VPWR sky130_fd_sc_hd__fill_1
X_3040_ net546 net355 net209 VGND VGND VPWR VPWR _0545_ sky130_fd_sc_hd__mux2_1
XTAP_TAPCELL_ROW_59_880 VGND VPWR sky130_fd_sc_hd__tapvpwrvgnd_1
X_4991_ clknet_leaf_19_clk _1046_ VGND VGND VPWR VPWR lsu.load_fifo.queue\[14\]\[12\]
+ sky130_fd_sc_hd__dfxtp_1
X_3942_ lsu.load_fifo.queue\[12\]\[8\] lsu.load_fifo.queue\[13\]\[8\] lsu.load_fifo.queue\[14\]\[8\]
+ lsu.load_fifo.queue\[15\]\[8\] net398 net381 VGND VGND VPWR VPWR _1391_ sky130_fd_sc_hd__mux4_1
X_3873_ lsu.load_fifo.queue\[0\]\[18\] lsu.load_fifo.queue\[1\]\[18\] lsu.load_fifo.queue\[2\]\[18\]
+ lsu.load_fifo.queue\[3\]\[18\] net386 net369 VGND VGND VPWR VPWR _1332_ sky130_fd_sc_hd__mux4_1
XTAP_TAPCELL_ROW_98_1307 VGND VPWR sky130_fd_sc_hd__tapvpwrvgnd_1
X_2824_ net319 net916 net226 VGND VGND VPWR VPWR _0337_ sky130_fd_sc_hd__mux2_1
X_2755_ net281 net949 _2027_ VGND VGND VPWR VPWR _0274_ sky130_fd_sc_hd__mux2_1
X_2686_ net684 net328 net230 VGND VGND VPWR VPWR _0210_ sky130_fd_sc_hd__mux2_1
XFILLER_105_529 VGND VGND VPWR VPWR sky130_fd_sc_hd__decap_4
X_4425_ clknet_leaf_78_clk _0482_ VGND VGND VPWR VPWR lsu.load_fifo.queue\[4\]\[1\]
+ sky130_fd_sc_hd__dfxtp_1
Xfanout404 net405 VGND VGND VPWR VPWR net404 sky130_fd_sc_hd__buf_2
X_4356_ clknet_leaf_12_clk _0413_ VGND VGND VPWR VPWR lsu.load_fifo.queue\[7\]\[30\]
+ sky130_fd_sc_hd__dfxtp_1
XFILLER_98_251 VGND VGND VPWR VPWR sky130_fd_sc_hd__fill_1
Xfanout426 net427 VGND VGND VPWR VPWR net426 sky130_fd_sc_hd__buf_4
Xfanout437 net438 VGND VGND VPWR VPWR net437 sky130_fd_sc_hd__buf_4
X_3307_ net1310 net61 net249 VGND VGND VPWR VPWR _0869_ sky130_fd_sc_hd__mux2_1
XFILLER_48_29 VGND VGND VPWR VPWR sky130_fd_sc_hd__decap_6
Xfanout415 lsu.store_fifo.r_ptr\[0\] VGND VGND VPWR VPWR net415 sky130_fd_sc_hd__buf_4
XFILLER_100_212 VGND VGND VPWR VPWR sky130_fd_sc_hd__fill_2
X_4287_ clknet_leaf_68_clk _0344_ VGND VGND VPWR VPWR lsu.load_fifo.queue\[9\]\[25\]
+ sky130_fd_sc_hd__dfxtp_1
X_3238_ net707 lsu.current_load_addr\[10\] net237 VGND VGND VPWR VPWR _0776_ sky130_fd_sc_hd__mux2_1
XFILLER_27_535 VGND VGND VPWR VPWR sky130_fd_sc_hd__decap_3
X_3169_ net1004 net294 net180 VGND VGND VPWR VPWR _0671_ sky130_fd_sc_hd__mux2_1
XFILLER_42_516 VGND VGND VPWR VPWR sky130_fd_sc_hd__decap_6
XFILLER_10_402 VPWR VGND VPWR VGND sky130_ef_sc_hd__decap_12
XFILLER_10_457 VPWR VGND VPWR VGND sky130_ef_sc_hd__decap_12
XFILLER_6_406 VPWR VGND VPWR VGND sky130_ef_sc_hd__decap_12
XTAP_TAPCELL_ROW_20_452 VGND VPWR sky130_fd_sc_hd__tapvpwrvgnd_1
XFILLER_89_69 VPWR VGND VPWR VGND sky130_ef_sc_hd__decap_12
XFILLER_2_601 VPWR VGND VPWR VGND sky130_ef_sc_hd__decap_12
XFILLER_1_111 VGND VGND VPWR VPWR sky130_fd_sc_hd__fill_1
Xhold480 lsu.load_fifo.queue\[6\]\[18\] VGND VGND VPWR VPWR net948 sky130_fd_sc_hd__dlygate4sd3_1
XFILLER_104_584 VGND VGND VPWR VPWR sky130_fd_sc_hd__decap_4
XFILLER_89_273 VGND VGND VPWR VPWR sky130_fd_sc_hd__decap_6
Xhold491 lsu.store_fifo.queue\[3\]\[0\] VGND VGND VPWR VPWR net959 sky130_fd_sc_hd__dlygate4sd3_1
XFILLER_1_177 VGND VGND VPWR VPWR sky130_fd_sc_hd__decap_6
Xclkbuf_leaf_84_clk clknet_3_0__leaf_clk VGND VGND VPWR VPWR clknet_leaf_84_clk sky130_fd_sc_hd__clkbuf_8
XTAP_TAPCELL_ROW_28_541 VGND VPWR sky130_fd_sc_hd__tapvpwrvgnd_1
XTAP_TAPCELL_ROW_56_850 VGND VPWR sky130_fd_sc_hd__tapvpwrvgnd_1
XFILLER_72_162 VGND VGND VPWR VPWR sky130_fd_sc_hd__fill_2
XFILLER_54_83 VGND VGND VPWR VPWR sky130_fd_sc_hd__fill_1
XFILLER_60_346 VGND VGND VPWR VPWR sky130_fd_sc_hd__fill_2
XFILLER_41_593 VGND VGND VPWR VPWR sky130_fd_sc_hd__decap_3
XFILLER_70_82 VGND VGND VPWR VPWR sky130_fd_sc_hd__fill_2
Xclkload25 clknet_leaf_78_clk VGND VGND VPWR VPWR clkload25/Y sky130_fd_sc_hd__bufinv_16
Xclkload14 clknet_leaf_7_clk VGND VGND VPWR VPWR clkload14/Y sky130_fd_sc_hd__clkinv_8
X_2540_ net1303 _1942_ net162 VGND VGND VPWR VPWR _0745_ sky130_fd_sc_hd__mux2_4
Xclkload47 clknet_leaf_29_clk VGND VGND VPWR VPWR clkload47/Y sky130_fd_sc_hd__inv_8
Xclkload69 clknet_leaf_36_clk VGND VGND VPWR VPWR clkload69/Y sky130_fd_sc_hd__clkinv_2
Xclkload36 clknet_leaf_22_clk VGND VGND VPWR VPWR clkload36/X sky130_fd_sc_hd__clkbuf_8
Xclkload58 clknet_leaf_73_clk VGND VGND VPWR VPWR clkload58/Y sky130_fd_sc_hd__inv_16
XTAP_TAPCELL_ROW_93_1248 VGND VPWR sky130_fd_sc_hd__tapvpwrvgnd_1
XFILLER_5_461 VPWR VGND VPWR VGND sky130_ef_sc_hd__decap_12
X_2471_ net1281 _1892_ _1893_ net252 VGND VGND VPWR VPWR _0797_ sky130_fd_sc_hd__o22a_1
X_4210_ clknet_leaf_54_clk _0267_ VGND VGND VPWR VPWR lsu.store_fifo.queue\[6\]\[8\]
+ sky130_fd_sc_hd__dfxtp_1
X_4141_ clknet_leaf_78_clk _0198_ VGND VGND VPWR VPWR lsu.load_fifo.queue\[11\]\[1\]
+ sky130_fd_sc_hd__dfxtp_1
XFILLER_83_405 VGND VGND VPWR VPWR sky130_fd_sc_hd__fill_1
X_4072_ _1447_ _1506_ VGND VGND VPWR VPWR _1507_ sky130_fd_sc_hd__nand2_1
XFILLER_83_449 VPWR VGND VPWR VGND sky130_ef_sc_hd__decap_12
XFILLER_83_427 VGND VGND VPWR VPWR sky130_fd_sc_hd__fill_2
X_3023_ net675 net322 net213 VGND VGND VPWR VPWR _0529_ sky130_fd_sc_hd__mux2_1
XFILLER_48_170 VGND VGND VPWR VPWR sky130_fd_sc_hd__fill_1
Xclkbuf_leaf_75_clk clknet_3_1__leaf_clk VGND VGND VPWR VPWR clknet_leaf_75_clk sky130_fd_sc_hd__clkbuf_8
X_4974_ clknet_leaf_77_clk _1029_ _0160_ VGND VGND VPWR VPWR acc.byte3\[3\] sky130_fd_sc_hd__dfrtp_1
XTAP_TAPCELL_ROW_102_1355 VGND VPWR sky130_fd_sc_hd__tapvpwrvgnd_1
X_3925_ net1264 _1376_ net253 VGND VGND VPWR VPWR _1013_ sky130_fd_sc_hd__mux2_1
XTAP_TAPCELL_ROW_34_599 VGND VPWR sky130_fd_sc_hd__tapvpwrvgnd_1
X_3856_ _1315_ _1317_ _1314_ _1316_ net358 net364 VGND VGND VPWR VPWR _1318_ sky130_fd_sc_hd__mux4_1
Xclkload8 clknet_leaf_1_clk VGND VGND VPWR VPWR clkload8/X sky130_fd_sc_hd__clkbuf_4
X_3787_ lsu.load_fifo.r_en _1258_ VGND VGND VPWR VPWR _1259_ sky130_fd_sc_hd__and2_1
X_2807_ net352 net1049 net227 VGND VGND VPWR VPWR _0320_ sky130_fd_sc_hd__mux2_1
X_2738_ _2014_ _2020_ VGND VGND VPWR VPWR _2026_ sky130_fd_sc_hd__nor2_4
XFILLER_105_304 VGND VGND VPWR VPWR sky130_fd_sc_hd__decap_8
X_4408_ clknet_leaf_31_clk _0465_ VGND VGND VPWR VPWR lsu.load_fifo.queue\[5\]\[16\]
+ sky130_fd_sc_hd__dfxtp_1
X_2669_ net896 net276 _2021_ VGND VGND VPWR VPWR _0194_ sky130_fd_sc_hd__mux2_1
XFILLER_59_39 VGND VGND VPWR VPWR sky130_fd_sc_hd__fill_1
Xfanout212 _2042_ VGND VGND VPWR VPWR net212 sky130_fd_sc_hd__buf_4
XTAP_TAPCELL_ROW_70_1001 VGND VPWR sky130_fd_sc_hd__tapvpwrvgnd_1
Xfanout201 _2057_ VGND VGND VPWR VPWR net201 sky130_fd_sc_hd__buf_2
Xfanout223 _2035_ VGND VGND VPWR VPWR net223 sky130_fd_sc_hd__clkbuf_4
Xfanout245 _1551_ VGND VGND VPWR VPWR net245 sky130_fd_sc_hd__buf_2
Xfanout256 _1259_ VGND VGND VPWR VPWR net256 sky130_fd_sc_hd__clkbuf_4
X_4339_ clknet_leaf_4_clk _0396_ VGND VGND VPWR VPWR lsu.load_fifo.queue\[7\]\[13\]
+ sky130_fd_sc_hd__dfxtp_1
Xfanout234 _2015_ VGND VGND VPWR VPWR net234 sky130_fd_sc_hd__clkbuf_4
Xfanout267 _1719_ VGND VGND VPWR VPWR net267 sky130_fd_sc_hd__clkbuf_2
XFILLER_74_405 VPWR VGND VPWR VGND sky130_ef_sc_hd__decap_12
Xfanout289 acc.data_out\[1\] VGND VGND VPWR VPWR net289 sky130_fd_sc_hd__dlymetal6s2s_1
Xfanout278 net279 VGND VGND VPWR VPWR net278 sky130_fd_sc_hd__clkbuf_2
XFILLER_59_457 VGND VGND VPWR VPWR sky130_fd_sc_hd__decap_6
XFILLER_46_129 VGND VGND VPWR VPWR sky130_fd_sc_hd__decap_4
Xclkbuf_leaf_66_clk clknet_3_5__leaf_clk VGND VGND VPWR VPWR clknet_leaf_66_clk sky130_fd_sc_hd__clkbuf_8
XFILLER_27_343 VGND VGND VPWR VPWR sky130_fd_sc_hd__fill_1
XFILLER_91_15 VPWR VGND VPWR VGND sky130_ef_sc_hd__decap_12
XFILLER_15_505 VPWR VGND VPWR VGND sky130_ef_sc_hd__decap_12
XTAP_TAPCELL_ROW_25_500 VGND VPWR sky130_fd_sc_hd__tapvpwrvgnd_1
XFILLER_40_85 VGND VGND VPWR VPWR sky130_fd_sc_hd__decap_4
XFILLER_2_475 VGND VGND VPWR VPWR sky130_fd_sc_hd__fill_1
XTAP_TAPCELL_ROW_5_280 VGND VPWR sky130_fd_sc_hd__tapvpwrvgnd_1
XFILLER_65_427 VGND VGND VPWR VPWR sky130_fd_sc_hd__fill_1
XFILLER_1_57 VPWR VGND VPWR VGND sky130_ef_sc_hd__decap_12
Xclkbuf_leaf_57_clk clknet_3_4__leaf_clk VGND VGND VPWR VPWR clknet_leaf_57_clk sky130_fd_sc_hd__clkbuf_8
XFILLER_18_398 VPWR VGND VPWR VGND sky130_ef_sc_hd__decap_12
XFILLER_33_335 VGND VGND VPWR VPWR sky130_fd_sc_hd__fill_1
X_3710_ acc.byte3\[3\] acc.byte2\[3\] VGND VGND VPWR VPWR _1192_ sky130_fd_sc_hd__or2_1
X_4690_ clknet_leaf_38_clk _0747_ _0036_ VGND VGND VPWR VPWR lsu.current_load_addr\[20\]
+ sky130_fd_sc_hd__dfrtp_1
X_3641_ net23 VGND VGND VPWR VPWR _1123_ sky130_fd_sc_hd__inv_2
XTAP_TAPCELL_ROW_31_569 VGND VPWR sky130_fd_sc_hd__tapvpwrvgnd_1
X_3572_ net422 VGND VGND VPWR VPWR _0136_ sky130_fd_sc_hd__inv_2
XFILLER_60_3 VGND VGND VPWR VPWR sky130_fd_sc_hd__fill_2
X_2523_ lsu.current_load_addr\[15\] _1928_ VGND VGND VPWR VPWR _1929_ sky130_fd_sc_hd__and2_1
XFILLER_102_318 VGND VGND VPWR VPWR sky130_fd_sc_hd__fill_2
X_2454_ _1851_ _1880_ net268 VGND VGND VPWR VPWR _1881_ sky130_fd_sc_hd__o21ai_1
X_2385_ lsu.store_counter\[11\] _1601_ _1797_ _1823_ VGND VGND VPWR VPWR _1824_ sky130_fd_sc_hd__o2bb2a_1
X_4124_ clknet_leaf_60_clk _0181_ VGND VGND VPWR VPWR lsu.store_fifo.queue\[11\]\[4\]
+ sky130_fd_sc_hd__dfxtp_1
XFILLER_96_585 VGND VGND VPWR VPWR sky130_fd_sc_hd__decap_3
Xinput1 arst_i VGND VGND VPWR VPWR net1 sky130_fd_sc_hd__clkbuf_1
XTAP_TAPCELL_ROW_67_967 VGND VPWR sky130_fd_sc_hd__tapvpwrvgnd_1
X_4055_ net270 _1490_ VGND VGND VPWR VPWR _1491_ sky130_fd_sc_hd__nor2_1
XTAP_TAPCELL_ROW_39_658 VGND VPWR sky130_fd_sc_hd__tapvpwrvgnd_1
Xclkbuf_leaf_48_clk clknet_3_7__leaf_clk VGND VGND VPWR VPWR clknet_leaf_48_clk sky130_fd_sc_hd__clkbuf_8
X_3006_ _1998_ _2041_ VGND VGND VPWR VPWR _2042_ sky130_fd_sc_hd__and2_2
XFILLER_36_195 VGND VGND VPWR VPWR sky130_fd_sc_hd__fill_1
XFILLER_101_69 VPWR VGND VPWR VGND sky130_ef_sc_hd__decap_12
X_4957_ clknet_leaf_22_clk _1012_ _0143_ VGND VGND VPWR VPWR acc.byte1\[2\] sky130_fd_sc_hd__dfrtp_1
X_3908_ lsu.load_fifo.queue\[0\]\[13\] lsu.load_fifo.queue\[1\]\[13\] lsu.load_fifo.queue\[2\]\[13\]
+ lsu.load_fifo.queue\[3\]\[13\] net385 net368 VGND VGND VPWR VPWR _1362_ sky130_fd_sc_hd__mux4_1
X_4888_ clknet_leaf_11_clk _0943_ VGND VGND VPWR VPWR lsu.load_fifo.queue\[12\]\[15\]
+ sky130_fd_sc_hd__dfxtp_1
X_3839_ lsu.load_fifo.queue\[4\]\[23\] lsu.load_fifo.queue\[5\]\[23\] lsu.load_fifo.queue\[6\]\[23\]
+ lsu.load_fifo.queue\[7\]\[23\] net388 net371 VGND VGND VPWR VPWR _1303_ sky130_fd_sc_hd__mux4_1
XFILLER_20_585 VGND VGND VPWR VPWR sky130_fd_sc_hd__decap_3
XFILLER_86_15 VPWR VGND VPWR VGND sky130_ef_sc_hd__decap_12
XFILLER_87_541 VGND VGND VPWR VPWR sky130_fd_sc_hd__decap_4
Xclkbuf_leaf_39_clk clknet_3_6__leaf_clk VGND VGND VPWR VPWR clknet_leaf_39_clk sky130_fd_sc_hd__clkbuf_8
XFILLER_47_449 VGND VGND VPWR VPWR sky130_fd_sc_hd__fill_1
XTAP_TAPCELL_ROW_2_250 VGND VPWR sky130_fd_sc_hd__tapvpwrvgnd_1
XFILLER_27_162 VGND VGND VPWR VPWR sky130_fd_sc_hd__decap_6
XFILLER_15_335 VGND VGND VPWR VPWR sky130_fd_sc_hd__fill_1
XFILLER_11_541 VPWR VGND VPWR VGND sky130_ef_sc_hd__decap_12
XFILLER_11_585 VPWR VGND VPWR VGND sky130_ef_sc_hd__decap_12
XFILLER_97_305 VPWR VGND VPWR VGND sky130_ef_sc_hd__decap_12
XTAP_TAPCELL_ROW_90_1218 VGND VPWR sky130_fd_sc_hd__tapvpwrvgnd_1
XFILLER_97_349 VGND VGND VPWR VPWR sky130_fd_sc_hd__decap_6
XPHY_EDGE_ROW_29_Left_136 VGND VGND VPWR VPWR sky130_fd_sc_hd__decap_3
XFILLER_78_563 VPWR VGND VPWR VGND sky130_ef_sc_hd__decap_12
X_2170_ net236 _1616_ _1584_ _1658_ VGND VGND VPWR VPWR _1660_ sky130_fd_sc_hd__and4_1
XFILLER_65_279 VGND VGND VPWR VPWR sky130_fd_sc_hd__fill_1
XTAP_TAPCELL_ROW_36_628 VGND VPWR sky130_fd_sc_hd__tapvpwrvgnd_1
XFILLER_46_471 VGND VGND VPWR VPWR sky130_fd_sc_hd__decap_4
XTAP_TAPCELL_ROW_64_937 VGND VPWR sky130_fd_sc_hd__tapvpwrvgnd_1
X_4811_ clknet_leaf_27_clk _0868_ VGND VGND VPWR VPWR lsu.load_fifo.data_in\[21\]
+ sky130_fd_sc_hd__dfxtp_1
XFILLER_21_316 VGND VGND VPWR VPWR sky130_fd_sc_hd__decap_4
XFILLER_33_165 VGND VGND VPWR VPWR sky130_fd_sc_hd__decap_3
XPHY_EDGE_ROW_38_Left_145 VGND VGND VPWR VPWR sky130_fd_sc_hd__decap_3
X_4742_ clknet_leaf_62_clk _0799_ _0056_ VGND VGND VPWR VPWR lsu.current_store_addr\[10\]
+ sky130_fd_sc_hd__dfrtp_1
X_4673_ clknet_leaf_28_clk _0730_ _0019_ VGND VGND VPWR VPWR lsu.current_load_addr\[3\]
+ sky130_fd_sc_hd__dfrtp_1
X_3624_ acc.start VGND VGND VPWR VPWR _1107_ sky130_fd_sc_hd__inv_2
X_3555_ net443 VGND VGND VPWR VPWR _0119_ sky130_fd_sc_hd__inv_2
XFILLER_0_209 VPWR VGND VPWR VGND sky130_ef_sc_hd__decap_12
XPHY_EDGE_ROW_47_Left_154 VGND VGND VPWR VPWR sky130_fd_sc_hd__decap_3
X_2506_ net363 _1915_ VGND VGND VPWR VPWR _1916_ sky130_fd_sc_hd__nand2_1
X_3486_ net432 VGND VGND VPWR VPWR _0050_ sky130_fd_sc_hd__inv_2
X_2437_ net88 net268 net241 VGND VGND VPWR VPWR _1869_ sky130_fd_sc_hd__o21a_1
X_2368_ lsu.store_counter\[7\] _1619_ _1622_ lsu.store_counter\[4\] _1802_ VGND VGND
+ VPWR VPWR _1807_ sky130_fd_sc_hd__a221oi_1
XFILLER_56_29 VGND VGND VPWR VPWR sky130_fd_sc_hd__fill_2
XFILLER_84_533 VGND VGND VPWR VPWR sky130_fd_sc_hd__decap_3
X_2299_ lsu.store_counter\[12\] _1752_ _1753_ _1730_ VGND VGND VPWR VPWR _0892_ sky130_fd_sc_hd__a22o_1
X_4107_ lsu.store_fifo.queue\[0\]\[0\] lsu.store_fifo.queue\[1\]\[0\] lsu.store_fifo.queue\[2\]\[0\]
+ lsu.store_fifo.queue\[3\]\[0\] net415 net409 VGND VGND VPWR VPWR _1538_ sky130_fd_sc_hd__mux4_1
X_4038_ net403 _1469_ _1471_ _1474_ _1475_ VGND VGND VPWR VPWR _1476_ sky130_fd_sc_hd__o32a_1
XFILLER_56_268 VGND VGND VPWR VPWR sky130_fd_sc_hd__fill_2
XPHY_EDGE_ROW_56_Left_163 VGND VGND VPWR VPWR sky130_fd_sc_hd__decap_3
XFILLER_12_305 VGND VGND VPWR VPWR sky130_fd_sc_hd__decap_3
XFILLER_21_32 VGND VGND VPWR VPWR sky130_fd_sc_hd__decap_3
XPHY_EDGE_ROW_65_Left_172 VGND VGND VPWR VPWR sky130_fd_sc_hd__decap_3
XTAP_TAPCELL_ROW_76_1062 VGND VPWR sky130_fd_sc_hd__tapvpwrvgnd_1
XFILLER_97_69 VPWR VGND VPWR VGND sky130_ef_sc_hd__decap_12
XFILLER_87_393 VGND VGND VPWR VPWR sky130_fd_sc_hd__decap_8
XPHY_EDGE_ROW_74_Left_181 VGND VGND VPWR VPWR sky130_fd_sc_hd__decap_3
XFILLER_47_279 VGND VGND VPWR VPWR sky130_fd_sc_hd__fill_1
XTAP_TAPCELL_ROW_87_1191 VGND VPWR sky130_fd_sc_hd__tapvpwrvgnd_1
XFILLER_55_290 VGND VGND VPWR VPWR sky130_fd_sc_hd__decap_6
XFILLER_62_72 VGND VGND VPWR VPWR sky130_fd_sc_hd__decap_3
XTAP_TAPCELL_ROW_13_377 VGND VPWR sky130_fd_sc_hd__tapvpwrvgnd_1
XFILLER_11_393 VPWR VGND VPWR VGND sky130_ef_sc_hd__decap_12
XFILLER_11_371 VPWR VGND VPWR VGND sky130_ef_sc_hd__decap_12
XTAP_TAPCELL_ROW_41_686 VGND VPWR sky130_fd_sc_hd__tapvpwrvgnd_1
XPHY_EDGE_ROW_83_Left_190 VGND VGND VPWR VPWR sky130_fd_sc_hd__decap_3
Xhold309 lsu.load_fifo.queue\[12\]\[11\] VGND VGND VPWR VPWR net777 sky130_fd_sc_hd__dlygate4sd3_1
XFILLER_7_386 VGND VGND VPWR VPWR sky130_fd_sc_hd__decap_6
X_3340_ net877 net310 net174 VGND VGND VPWR VPWR _0950_ sky130_fd_sc_hd__mux2_1
XFILLER_97_113 VPWR VGND VPWR VGND sky130_ef_sc_hd__decap_12
X_3271_ lsu.current_store_addr\[20\] net924 _2052_ VGND VGND VPWR VPWR _0831_ sky130_fd_sc_hd__mux2_1
X_5010_ clknet_leaf_75_clk _1065_ VGND VGND VPWR VPWR lsu.load_fifo.queue\[14\]\[31\]
+ sky130_fd_sc_hd__dfxtp_1
X_2222_ net1312 _1698_ _1696_ VGND VGND VPWR VPWR _0914_ sky130_fd_sc_hd__o21ba_1
X_2153_ _1640_ _1642_ _1637_ VGND VGND VPWR VPWR _1643_ sky130_fd_sc_hd__o21ai_1
XTAP_TAPCELL_ROW_49_764 VGND VPWR sky130_fd_sc_hd__tapvpwrvgnd_1
X_2084_ net11 _1565_ VGND VGND VPWR VPWR _1574_ sky130_fd_sc_hd__xor2_4
XFILLER_22_625 VGND VGND VPWR VPWR sky130_fd_sc_hd__decap_4
XFILLER_21_113 VGND VGND VPWR VPWR sky130_fd_sc_hd__fill_2
XFILLER_21_135 VPWR VGND VPWR VGND sky130_ef_sc_hd__decap_12
XFILLER_61_293 VGND VGND VPWR VPWR sky130_fd_sc_hd__decap_4
X_2986_ net889 net328 net189 VGND VGND VPWR VPWR _0494_ sky130_fd_sc_hd__mux2_1
X_4725_ clknet_leaf_29_clk _0782_ VGND VGND VPWR VPWR net111 sky130_fd_sc_hd__dfxtp_1
X_4656_ clknet_leaf_64_clk _0713_ _0012_ VGND VGND VPWR VPWR lsu.store_fifo.r_ptr\[0\]
+ sky130_fd_sc_hd__dfrtp_1
Xhold810 lsu.acc_state\[0\] VGND VGND VPWR VPWR net1278 sky130_fd_sc_hd__dlygate4sd3_1
X_4587_ clknet_leaf_85_clk _0644_ VGND VGND VPWR VPWR lsu.load_fifo.queue\[8\]\[3\]
+ sky130_fd_sc_hd__dfxtp_1
Xhold821 acc.byte1\[0\] VGND VGND VPWR VPWR net1289 sky130_fd_sc_hd__dlygate4sd3_1
X_3607_ net434 VGND VGND VPWR VPWR _0171_ sky130_fd_sc_hd__inv_2
Xinput81 store_base_addr[10] VGND VGND VPWR VPWR net81 sky130_fd_sc_hd__clkbuf_1
Xinput70 load_data[30] VGND VGND VPWR VPWR net70 sky130_fd_sc_hd__buf_1
Xinput92 store_base_addr[20] VGND VGND VPWR VPWR net92 sky130_fd_sc_hd__clkbuf_1
X_3538_ net437 VGND VGND VPWR VPWR _0102_ sky130_fd_sc_hd__inv_2
XFILLER_89_614 VGND VGND VPWR VPWR sky130_fd_sc_hd__fill_2
Xhold832 acc.byte1\[2\] VGND VGND VPWR VPWR net1300 sky130_fd_sc_hd__dlygate4sd3_1
Xhold843 lsu.current_store_addr\[10\] VGND VGND VPWR VPWR net1311 sky130_fd_sc_hd__dlygate4sd3_1
XFILLER_1_529 VPWR VGND VPWR VGND sky130_ef_sc_hd__decap_12
X_3469_ net427 VGND VGND VPWR VPWR _0033_ sky130_fd_sc_hd__inv_2
XFILLER_84_363 VGND VGND VPWR VPWR sky130_fd_sc_hd__fill_1
XFILLER_57_577 VGND VGND VPWR VPWR sky130_fd_sc_hd__fill_1
XFILLER_84_385 VGND VGND VPWR VPWR sky130_fd_sc_hd__fill_1
XFILLER_72_525 VGND VGND VPWR VPWR sky130_fd_sc_hd__decap_6
XFILLER_25_430 VGND VGND VPWR VPWR sky130_fd_sc_hd__decap_8
XFILLER_16_54 VGND VGND VPWR VPWR sky130_fd_sc_hd__decap_6
XFILLER_12_157 VGND VGND VPWR VPWR sky130_fd_sc_hd__fill_1
XFILLER_9_629 VGND VGND VPWR VPWR sky130_fd_sc_hd__fill_1
XFILLER_40_477 VGND VGND VPWR VPWR sky130_fd_sc_hd__decap_4
XTAP_TAPCELL_ROW_10_336 VGND VPWR sky130_fd_sc_hd__tapvpwrvgnd_1
XFILLER_79_113 VGND VGND VPWR VPWR sky130_fd_sc_hd__fill_2
XFILLER_4_389 VPWR VGND VPWR VGND sky130_ef_sc_hd__decap_12
XFILLER_0_573 VGND VGND VPWR VPWR sky130_fd_sc_hd__decap_8
XTAP_TAPCELL_ROW_18_425 VGND VPWR sky130_fd_sc_hd__tapvpwrvgnd_1
XTAP_TAPCELL_ROW_46_734 VGND VPWR sky130_fd_sc_hd__tapvpwrvgnd_1
XFILLER_63_536 VGND VGND VPWR VPWR sky130_fd_sc_hd__fill_1
XFILLER_90_355 VGND VGND VPWR VPWR sky130_fd_sc_hd__decap_8
XFILLER_90_399 VGND VGND VPWR VPWR sky130_fd_sc_hd__fill_1
XFILLER_90_377 VGND VGND VPWR VPWR sky130_fd_sc_hd__fill_1
X_2840_ net503 net355 net225 VGND VGND VPWR VPWR _0351_ sky130_fd_sc_hd__mux2_1
XFILLER_43_271 VGND VGND VPWR VPWR sky130_fd_sc_hd__decap_8
XFILLER_31_499 VGND VGND VPWR VPWR sky130_fd_sc_hd__decap_4
X_2771_ lsu.store_fifo.w_ptr\[3\] lsu.store_fifo.w_ptr\[2\] VGND VGND VPWR VPWR _2029_
+ sky130_fd_sc_hd__or2_2
X_4510_ clknet_leaf_72_clk _0567_ VGND VGND VPWR VPWR lsu.load_fifo.queue\[2\]\[22\]
+ sky130_fd_sc_hd__dfxtp_1
Xhold117 net117 VGND VGND VPWR VPWR net585 sky130_fd_sc_hd__dlygate4sd3_1
X_4441_ clknet_leaf_80_clk _0498_ VGND VGND VPWR VPWR lsu.load_fifo.queue\[4\]\[17\]
+ sky130_fd_sc_hd__dfxtp_1
Xhold106 lsu.load_fifo.queue\[10\]\[30\] VGND VGND VPWR VPWR net574 sky130_fd_sc_hd__dlygate4sd3_1
Xhold139 net107 VGND VGND VPWR VPWR net607 sky130_fd_sc_hd__dlygate4sd3_1
Xhold128 lsu.load_fifo.queue\[0\]\[27\] VGND VGND VPWR VPWR net596 sky130_fd_sc_hd__dlygate4sd3_1
XPHY_EDGE_ROW_9_Right_9 VGND VGND VPWR VPWR sky130_fd_sc_hd__decap_3
X_4372_ clknet_leaf_19_clk _0429_ VGND VGND VPWR VPWR lsu.load_fifo.queue\[6\]\[12\]
+ sky130_fd_sc_hd__dfxtp_1
XFILLER_98_433 VGND VGND VPWR VPWR sky130_fd_sc_hd__decap_8
X_3323_ net694 net344 net173 VGND VGND VPWR VPWR _0933_ sky130_fd_sc_hd__mux2_1
X_3254_ lsu.current_store_addr\[3\] net748 net257 VGND VGND VPWR VPWR _0814_ sky130_fd_sc_hd__mux2_1
X_2205_ _1099_ _1687_ _1688_ _1679_ VGND VGND VPWR VPWR _0921_ sky130_fd_sc_hd__a2bb2o_1
XFILLER_100_438 VPWR VGND VPWR VGND sky130_ef_sc_hd__decap_12
XFILLER_100_427 VGND VGND VPWR VPWR sky130_fd_sc_hd__decap_4
X_3185_ net672 net328 net202 VGND VGND VPWR VPWR _0686_ sky130_fd_sc_hd__mux2_1
X_2136_ lsu.load_counter\[6\] _1620_ _1624_ lsu.load_counter\[5\] VGND VGND VPWR VPWR
+ _1626_ sky130_fd_sc_hd__a22o_1
X_2067_ _1555_ net18 _1124_ _1553_ VGND VGND VPWR VPWR _1557_ sky130_fd_sc_hd__and4bb_2
XFILLER_93_193 VPWR VGND VPWR VGND sky130_ef_sc_hd__decap_12
XTAP_TAPCELL_ROW_105_1386 VGND VPWR sky130_fd_sc_hd__tapvpwrvgnd_1
XFILLER_62_580 VGND VGND VPWR VPWR sky130_fd_sc_hd__decap_8
X_2969_ net292 net1051 net215 VGND VGND VPWR VPWR _0480_ sky130_fd_sc_hd__mux2_1
X_4708_ clknet_leaf_45_clk _0765_ _0044_ VGND VGND VPWR VPWR lsu.storer_state\[2\]
+ sky130_fd_sc_hd__dfrtp_2
X_4639_ clknet_leaf_80_clk _0696_ VGND VGND VPWR VPWR lsu.load_fifo.queue\[15\]\[23\]
+ sky130_fd_sc_hd__dfxtp_1
XFILLER_89_422 VGND VGND VPWR VPWR sky130_fd_sc_hd__decap_3
XTAP_TAPCELL_ROW_73_1032 VGND VPWR sky130_fd_sc_hd__tapvpwrvgnd_1
Xhold640 lsu.store_fifo.queue\[9\]\[0\] VGND VGND VPWR VPWR net1108 sky130_fd_sc_hd__dlygate4sd3_1
Xhold651 lsu.store_fifo.queue\[11\]\[7\] VGND VGND VPWR VPWR net1119 sky130_fd_sc_hd__dlygate4sd3_1
Xhold662 lsu.load_fifo.queue\[4\]\[22\] VGND VGND VPWR VPWR net1130 sky130_fd_sc_hd__dlygate4sd3_1
Xhold684 lsu.load_fifo.queue\[5\]\[7\] VGND VGND VPWR VPWR net1152 sky130_fd_sc_hd__dlygate4sd3_1
Xhold695 lsu.load_fifo.queue\[2\]\[20\] VGND VGND VPWR VPWR net1163 sky130_fd_sc_hd__dlygate4sd3_1
XFILLER_1_337 VGND VGND VPWR VPWR sky130_fd_sc_hd__decap_8
Xhold673 lsu.load_fifo.queue\[5\]\[11\] VGND VGND VPWR VPWR net1141 sky130_fd_sc_hd__dlygate4sd3_1
XFILLER_94_15 VPWR VGND VPWR VGND sky130_ef_sc_hd__decap_12
XFILLER_45_503 VGND VGND VPWR VPWR sky130_fd_sc_hd__fill_1
XTAP_TAPCELL_ROW_84_1150 VGND VPWR sky130_fd_sc_hd__tapvpwrvgnd_1
XTAP_TAPCELL_ROW_43_704 VGND VPWR sky130_fd_sc_hd__tapvpwrvgnd_1
XTAP_TAPCELL_ROW_23_483 VGND VPWR sky130_fd_sc_hd__tapvpwrvgnd_1
XTAP_TAPCELL_ROW_51_792 VGND VPWR sky130_fd_sc_hd__tapvpwrvgnd_1
XFILLER_99_219 VGND VGND VPWR VPWR sky130_fd_sc_hd__decap_4
XFILLER_68_60 VPWR VGND VPWR VGND sky130_ef_sc_hd__decap_12
XFILLER_68_82 VGND VGND VPWR VPWR sky130_fd_sc_hd__fill_2
XFILLER_48_341 VGND VGND VPWR VPWR sky130_fd_sc_hd__decap_8
XFILLER_48_363 VGND VGND VPWR VPWR sky130_fd_sc_hd__fill_1
XTAP_TAPCELL_ROW_59_881 VGND VPWR sky130_fd_sc_hd__tapvpwrvgnd_1
XFILLER_90_130 VGND VGND VPWR VPWR sky130_fd_sc_hd__decap_8
X_4990_ clknet_leaf_85_clk _1045_ VGND VGND VPWR VPWR lsu.load_fifo.queue\[14\]\[11\]
+ sky130_fd_sc_hd__dfxtp_1
X_3941_ lsu.load_fifo.queue\[0\]\[8\] lsu.load_fifo.queue\[1\]\[8\] lsu.load_fifo.queue\[2\]\[8\]
+ lsu.load_fifo.queue\[3\]\[8\] net398 net378 VGND VGND VPWR VPWR _1390_ sky130_fd_sc_hd__mux4_1
XFILLER_90_3 VPWR VGND VPWR VGND sky130_ef_sc_hd__decap_12
X_3872_ lsu.load_fifo.queue\[4\]\[18\] lsu.load_fifo.queue\[5\]\[18\] lsu.load_fifo.queue\[6\]\[18\]
+ lsu.load_fifo.queue\[7\]\[18\] net384 net367 VGND VGND VPWR VPWR _1331_ sky130_fd_sc_hd__mux4_1
XTAP_TAPCELL_ROW_98_1308 VGND VPWR sky130_fd_sc_hd__tapvpwrvgnd_1
X_2823_ net321 net1235 net227 VGND VGND VPWR VPWR _0336_ sky130_fd_sc_hd__mux2_1
X_2754_ net282 net1233 _2027_ VGND VGND VPWR VPWR _0273_ sky130_fd_sc_hd__mux2_1
X_2685_ net567 net330 net232 VGND VGND VPWR VPWR _0209_ sky130_fd_sc_hd__mux2_1
X_4424_ clknet_leaf_34_clk _0481_ VGND VGND VPWR VPWR lsu.load_fifo.queue\[4\]\[0\]
+ sky130_fd_sc_hd__dfxtp_1
X_4355_ clknet_leaf_22_clk _0412_ VGND VGND VPWR VPWR lsu.load_fifo.queue\[7\]\[29\]
+ sky130_fd_sc_hd__dfxtp_1
Xfanout405 lsu.store_fifo.r_ptr\[2\] VGND VGND VPWR VPWR net405 sky130_fd_sc_hd__clkbuf_2
X_3306_ net313 net60 net250 VGND VGND VPWR VPWR _0868_ sky130_fd_sc_hd__mux2_1
Xfanout438 net439 VGND VGND VPWR VPWR net438 sky130_fd_sc_hd__buf_4
Xfanout416 lsu.load_fifo.w_ptr\[3\] VGND VGND VPWR VPWR net416 sky130_fd_sc_hd__buf_2
Xfanout427 net429 VGND VGND VPWR VPWR net427 sky130_fd_sc_hd__clkbuf_4
XFILLER_100_202 VGND VGND VPWR VPWR sky130_fd_sc_hd__fill_1
X_4286_ clknet_leaf_37_clk _0343_ VGND VGND VPWR VPWR lsu.load_fifo.queue\[9\]\[24\]
+ sky130_fd_sc_hd__dfxtp_1
XFILLER_58_127 VGND VGND VPWR VPWR sky130_fd_sc_hd__decap_4
X_3237_ net772 lsu.current_load_addr\[9\] net237 VGND VGND VPWR VPWR _0775_ sky130_fd_sc_hd__mux2_1
XFILLER_74_609 VGND VGND VPWR VPWR sky130_fd_sc_hd__fill_1
XFILLER_39_330 VGND VGND VPWR VPWR sky130_fd_sc_hd__decap_6
XFILLER_58_149 VGND VGND VPWR VPWR sky130_fd_sc_hd__fill_1
X_3168_ net629 net297 net179 VGND VGND VPWR VPWR _0670_ sky130_fd_sc_hd__mux2_1
X_2119_ net23 _1557_ VGND VGND VPWR VPWR _1609_ sky130_fd_sc_hd__xnor2_2
X_3099_ net302 net1167 net187 VGND VGND VPWR VPWR _0603_ sky130_fd_sc_hd__mux2_1
XFILLER_10_414 VGND VGND VPWR VPWR sky130_fd_sc_hd__decap_6
XFILLER_10_469 VGND VGND VPWR VPWR sky130_fd_sc_hd__decap_6
XFILLER_89_15 VPWR VGND VPWR VGND sky130_ef_sc_hd__decap_12
XFILLER_6_418 VGND VGND VPWR VPWR sky130_fd_sc_hd__fill_2
XTAP_TAPCELL_ROW_20_453 VGND VPWR sky130_fd_sc_hd__tapvpwrvgnd_1
XFILLER_2_613 VPWR VGND VPWR VGND sky130_ef_sc_hd__decap_12
Xhold470 lsu.load_fifo.queue\[5\]\[17\] VGND VGND VPWR VPWR net938 sky130_fd_sc_hd__dlygate4sd3_1
Xhold481 lsu.store_fifo.queue\[5\]\[5\] VGND VGND VPWR VPWR net949 sky130_fd_sc_hd__dlygate4sd3_1
Xhold492 lsu.load_fifo.queue\[13\]\[7\] VGND VGND VPWR VPWR net960 sky130_fd_sc_hd__dlygate4sd3_1
XFILLER_1_156 VPWR VGND VPWR VGND sky130_ef_sc_hd__decap_12
XFILLER_38_52 VGND VGND VPWR VPWR sky130_fd_sc_hd__fill_1
XFILLER_49_149 VGND VGND VPWR VPWR sky130_fd_sc_hd__decap_3
XFILLER_38_85 VGND VGND VPWR VPWR sky130_fd_sc_hd__decap_6
XTAP_TAPCELL_ROW_28_542 VGND VPWR sky130_fd_sc_hd__tapvpwrvgnd_1
XTAP_TAPCELL_ROW_56_851 VGND VPWR sky130_fd_sc_hd__tapvpwrvgnd_1
XFILLER_45_355 VPWR VGND VPWR VGND sky130_ef_sc_hd__decap_12
XFILLER_70_61 VGND VGND VPWR VPWR sky130_fd_sc_hd__decap_4
Xclkload15 clknet_leaf_84_clk VGND VGND VPWR VPWR clkload15/Y sky130_fd_sc_hd__clkinvlp_4
Xclkload26 clknet_leaf_79_clk VGND VGND VPWR VPWR clkload26/Y sky130_fd_sc_hd__inv_8
Xclkload48 clknet_leaf_30_clk VGND VGND VPWR VPWR clkload48/Y sky130_fd_sc_hd__clkinv_4
Xclkload37 clknet_leaf_23_clk VGND VGND VPWR VPWR clkload37/Y sky130_fd_sc_hd__bufinv_16
Xclkload59 clknet_leaf_49_clk VGND VGND VPWR VPWR clkload59/Y sky130_fd_sc_hd__bufinv_16
XTAP_TAPCELL_ROW_93_1249 VGND VPWR sky130_fd_sc_hd__tapvpwrvgnd_1
XFILLER_5_473 VPWR VGND VPWR VGND sky130_ef_sc_hd__decap_12
X_2470_ net100 _1848_ net269 VGND VGND VPWR VPWR _1893_ sky130_fd_sc_hd__mux2_1
XPHY_EDGE_ROW_10_Left_117 VGND VGND VPWR VPWR sky130_fd_sc_hd__decap_3
X_4140_ clknet_leaf_35_clk _0197_ VGND VGND VPWR VPWR lsu.load_fifo.queue\[11\]\[0\]
+ sky130_fd_sc_hd__dfxtp_1
X_4071_ net404 _1499_ _1501_ _1504_ _1505_ VGND VGND VPWR VPWR _1506_ sky130_fd_sc_hd__o32a_1
X_3022_ net1139 net325 net213 VGND VGND VPWR VPWR _0528_ sky130_fd_sc_hd__mux2_1
XFILLER_24_528 VGND VGND VPWR VPWR sky130_fd_sc_hd__decap_4
X_4973_ clknet_leaf_9_clk _1028_ _0159_ VGND VGND VPWR VPWR acc.byte3\[2\] sky130_fd_sc_hd__dfrtp_1
XFILLER_63_185 VGND VGND VPWR VPWR sky130_fd_sc_hd__decap_6
X_3924_ _1375_ _1372_ net356 VGND VGND VPWR VPWR _1376_ sky130_fd_sc_hd__mux2_1
XTAP_TAPCELL_ROW_102_1356 VGND VPWR sky130_fd_sc_hd__tapvpwrvgnd_1
X_3855_ lsu.load_fifo.queue\[8\]\[21\] lsu.load_fifo.queue\[9\]\[21\] lsu.load_fifo.queue\[10\]\[21\]
+ lsu.load_fifo.queue\[11\]\[21\] net394 net377 VGND VGND VPWR VPWR _1317_ sky130_fd_sc_hd__mux4_1
Xclkload9 clknet_leaf_2_clk VGND VGND VPWR VPWR clkload9/Y sky130_fd_sc_hd__clkinvlp_4
X_3786_ _1253_ _1255_ _1256_ _1257_ VGND VGND VPWR VPWR _1258_ sky130_fd_sc_hd__or4b_1
X_2806_ net355 net729 net229 VGND VGND VPWR VPWR _0319_ sky130_fd_sc_hd__mux2_1
X_2737_ net272 net1202 net234 VGND VGND VPWR VPWR _0258_ sky130_fd_sc_hd__mux2_1
X_2668_ net516 net278 _2021_ VGND VGND VPWR VPWR _0193_ sky130_fd_sc_hd__mux2_1
X_4407_ clknet_leaf_11_clk _0464_ VGND VGND VPWR VPWR lsu.load_fifo.queue\[5\]\[15\]
+ sky130_fd_sc_hd__dfxtp_1
X_2599_ lsu.current_load_addr\[1\] lsu.current_load_addr\[0\] lsu.current_load_addr\[2\]
+ VGND VGND VPWR VPWR _1986_ sky130_fd_sc_hd__a21o_1
Xfanout213 _2042_ VGND VGND VPWR VPWR net213 sky130_fd_sc_hd__buf_2
XTAP_TAPCELL_ROW_70_1002 VGND VPWR sky130_fd_sc_hd__tapvpwrvgnd_1
Xfanout202 _2047_ VGND VGND VPWR VPWR net202 sky130_fd_sc_hd__buf_4
XFILLER_99_583 VPWR VGND VPWR VGND sky130_ef_sc_hd__decap_12
Xfanout246 net247 VGND VGND VPWR VPWR net246 sky130_fd_sc_hd__buf_2
Xfanout224 _2035_ VGND VGND VPWR VPWR net224 sky130_fd_sc_hd__buf_4
X_4338_ clknet_leaf_19_clk _0395_ VGND VGND VPWR VPWR lsu.load_fifo.queue\[7\]\[12\]
+ sky130_fd_sc_hd__dfxtp_1
Xfanout268 net269 VGND VGND VPWR VPWR net268 sky130_fd_sc_hd__clkbuf_4
X_4269_ clknet_leaf_32_clk _0326_ VGND VGND VPWR VPWR lsu.load_fifo.queue\[9\]\[7\]
+ sky130_fd_sc_hd__dfxtp_1
Xfanout257 _2052_ VGND VGND VPWR VPWR net257 sky130_fd_sc_hd__clkbuf_4
Xfanout279 acc.data_out\[6\] VGND VGND VPWR VPWR net279 sky130_fd_sc_hd__clkbuf_2
XFILLER_74_417 VGND VGND VPWR VPWR sky130_fd_sc_hd__decap_3
XFILLER_15_517 VPWR VGND VPWR VGND sky130_ef_sc_hd__decap_12
XFILLER_91_27 VPWR VGND VPWR VGND sky130_ef_sc_hd__decap_12
XTAP_TAPCELL_ROW_25_501 VGND VPWR sky130_fd_sc_hd__tapvpwrvgnd_1
XTAP_TAPCELL_ROW_53_810 VGND VPWR sky130_fd_sc_hd__tapvpwrvgnd_1
XTAP_TAPCELL_ROW_81_1120 VGND VPWR sky130_fd_sc_hd__tapvpwrvgnd_1
XFILLER_24_21 VGND VGND VPWR VPWR sky130_fd_sc_hd__decap_6
XFILLER_42_358 VGND VGND VPWR VPWR sky130_fd_sc_hd__decap_6
XFILLER_2_421 VPWR VGND VPWR VGND sky130_ef_sc_hd__decap_12
XTAP_TAPCELL_ROW_5_281 VGND VPWR sky130_fd_sc_hd__tapvpwrvgnd_1
XFILLER_65_439 VGND VGND VPWR VPWR sky130_fd_sc_hd__decap_8
XFILLER_1_69 VPWR VGND VPWR VGND sky130_ef_sc_hd__decap_12
XFILLER_18_322 VGND VGND VPWR VPWR sky130_fd_sc_hd__decap_4
XFILLER_73_461 VPWR VGND VPWR VGND sky130_ef_sc_hd__decap_12
XFILLER_45_130 VGND VGND VPWR VPWR sky130_fd_sc_hd__decap_4
XFILLER_45_152 VPWR VGND VPWR VGND sky130_ef_sc_hd__decap_12
XFILLER_33_314 VGND VGND VPWR VPWR sky130_fd_sc_hd__fill_1
X_3640_ net3 VGND VGND VPWR VPWR _1122_ sky130_fd_sc_hd__inv_2
X_3571_ net427 VGND VGND VPWR VPWR _0135_ sky130_fd_sc_hd__inv_2
X_2522_ lsu.current_load_addr\[14\] lsu.current_load_addr\[13\] _1927_ VGND VGND VPWR
+ VPWR _1928_ sky130_fd_sc_hd__and3_1
X_2453_ lsu.current_store_addr\[12\] _1849_ VGND VGND VPWR VPWR _1880_ sky130_fd_sc_hd__nor2_1
XFILLER_5_292 VGND VGND VPWR VPWR sky130_fd_sc_hd__decap_4
XFILLER_96_531 VGND VGND VPWR VPWR sky130_fd_sc_hd__fill_1
X_2384_ _1798_ _1799_ VGND VGND VPWR VPWR _1823_ sky130_fd_sc_hd__and2b_1
X_4123_ clknet_leaf_67_clk _0180_ VGND VGND VPWR VPWR lsu.store_fifo.queue\[11\]\[3\]
+ sky130_fd_sc_hd__dfxtp_1
Xinput2 count[0] VGND VGND VPWR VPWR net2 sky130_fd_sc_hd__buf_4
X_4054_ lsu.store_fifo.queue\[8\]\[5\] lsu.store_fifo.queue\[9\]\[5\] lsu.store_fifo.queue\[10\]\[5\]
+ lsu.store_fifo.queue\[11\]\[5\] net412 net407 VGND VGND VPWR VPWR _1490_ sky130_fd_sc_hd__mux4_1
X_3005_ net416 net419 VGND VGND VPWR VPWR _2041_ sky130_fd_sc_hd__nor2_1
XTAP_TAPCELL_ROW_67_968 VGND VPWR sky130_fd_sc_hd__tapvpwrvgnd_1
XTAP_TAPCELL_ROW_39_659 VGND VPWR sky130_fd_sc_hd__tapvpwrvgnd_1
XFILLER_64_461 VGND VGND VPWR VPWR sky130_fd_sc_hd__fill_1
X_4956_ clknet_leaf_9_clk _1011_ _0142_ VGND VGND VPWR VPWR acc.byte1\[1\] sky130_fd_sc_hd__dfrtp_1
X_4887_ clknet_leaf_0_clk _0942_ VGND VGND VPWR VPWR lsu.load_fifo.queue\[12\]\[14\]
+ sky130_fd_sc_hd__dfxtp_1
X_3907_ lsu.load_fifo.queue\[4\]\[13\] lsu.load_fifo.queue\[5\]\[13\] lsu.load_fifo.queue\[6\]\[13\]
+ lsu.load_fifo.queue\[7\]\[13\] net385 net368 VGND VGND VPWR VPWR _1361_ sky130_fd_sc_hd__mux4_1
X_3838_ _1300_ _1301_ net361 VGND VGND VPWR VPWR _1302_ sky130_fd_sc_hd__mux2_1
XFILLER_106_625 VGND VGND VPWR VPWR sky130_fd_sc_hd__fill_2
X_3769_ _1219_ _1242_ VGND VGND VPWR VPWR _1243_ sky130_fd_sc_hd__nor2_1
XFILLER_86_27 VGND VGND VPWR VPWR sky130_fd_sc_hd__fill_1
XFILLER_99_391 VGND VGND VPWR VPWR sky130_fd_sc_hd__fill_1
XTAP_TAPCELL_ROW_2_251 VGND VPWR sky130_fd_sc_hd__tapvpwrvgnd_1
XFILLER_27_152 VGND VGND VPWR VPWR sky130_fd_sc_hd__fill_1
XFILLER_42_111 VGND VGND VPWR VPWR sky130_fd_sc_hd__decap_8
XFILLER_70_475 VGND VGND VPWR VPWR sky130_fd_sc_hd__fill_1
XFILLER_11_553 VGND VGND VPWR VPWR sky130_fd_sc_hd__decap_6
XFILLER_11_597 VPWR VGND VPWR VGND sky130_ef_sc_hd__decap_12
XTAP_TAPCELL_ROW_90_1219 VGND VPWR sky130_fd_sc_hd__tapvpwrvgnd_1
XFILLER_97_317 VPWR VGND VPWR VGND sky130_ef_sc_hd__decap_12
XFILLER_78_542 VGND VGND VPWR VPWR sky130_fd_sc_hd__decap_4
XFILLER_78_575 VPWR VGND VPWR VGND sky130_ef_sc_hd__decap_12
XFILLER_18_141 VGND VGND VPWR VPWR sky130_fd_sc_hd__decap_6
XTAP_TAPCELL_ROW_36_629 VGND VPWR sky130_fd_sc_hd__tapvpwrvgnd_1
XTAP_TAPCELL_ROW_64_938 VGND VPWR sky130_fd_sc_hd__tapvpwrvgnd_1
X_4810_ clknet_leaf_86_clk _0867_ VGND VGND VPWR VPWR lsu.load_fifo.data_in\[20\]
+ sky130_fd_sc_hd__dfxtp_1
X_4741_ clknet_leaf_61_clk _0798_ _0055_ VGND VGND VPWR VPWR lsu.current_store_addr\[9\]
+ sky130_fd_sc_hd__dfrtp_2
X_4672_ clknet_leaf_28_clk _0729_ _0018_ VGND VGND VPWR VPWR lsu.current_load_addr\[2\]
+ sky130_fd_sc_hd__dfrtp_1
X_3623_ lsu.acc_state\[1\] VGND VGND VPWR VPWR _1106_ sky130_fd_sc_hd__inv_2
X_3554_ net443 VGND VGND VPWR VPWR _0118_ sky130_fd_sc_hd__inv_2
XFILLER_103_617 VGND VGND VPWR VPWR sky130_fd_sc_hd__decap_8
X_3485_ net441 VGND VGND VPWR VPWR _0049_ sky130_fd_sc_hd__inv_2
X_2505_ net381 net395 net255 VGND VGND VPWR VPWR _1915_ sky130_fd_sc_hd__and3_1
X_2436_ _1854_ _1867_ net268 VGND VGND VPWR VPWR _1868_ sky130_fd_sc_hd__o21ai_1
X_2367_ lsu.store_counter\[6\] _1620_ VGND VGND VPWR VPWR _1806_ sky130_fd_sc_hd__nand2_1
X_2298_ lsu.store_counter\[12\] _1721_ VGND VGND VPWR VPWR _1753_ sky130_fd_sc_hd__nor2_1
X_4106_ net1246 net246 _1537_ VGND VGND VPWR VPWR _0993_ sky130_fd_sc_hd__o21a_1
X_4037_ net400 _1472_ net403 VGND VGND VPWR VPWR _1475_ sky130_fd_sc_hd__o21ai_1
XFILLER_44_409 VGND VGND VPWR VPWR sky130_fd_sc_hd__fill_1
XFILLER_64_291 VGND VGND VPWR VPWR sky130_fd_sc_hd__fill_1
XFILLER_52_475 VGND VGND VPWR VPWR sky130_fd_sc_hd__fill_1
X_4939_ clknet_leaf_63_clk _0994_ _0125_ VGND VGND VPWR VPWR net151 sky130_fd_sc_hd__dfrtp_1
XFILLER_21_55 VGND VGND VPWR VPWR sky130_fd_sc_hd__fill_1
XFILLER_97_15 VPWR VGND VPWR VGND sky130_ef_sc_hd__decap_12
XTAP_TAPCELL_ROW_76_1063 VGND VPWR sky130_fd_sc_hd__tapvpwrvgnd_1
XTAP_TAPCELL_ROW_7_310 VGND VPWR sky130_fd_sc_hd__tapvpwrvgnd_1
XFILLER_94_309 VPWR VGND VPWR VGND sky130_ef_sc_hd__decap_12
XFILLER_87_361 VPWR VGND VPWR VGND sky130_ef_sc_hd__decap_12
XFILLER_101_182 VGND VGND VPWR VPWR sky130_fd_sc_hd__fill_1
XFILLER_47_225 VPWR VGND VPWR VGND sky130_ef_sc_hd__decap_12
XFILLER_35_409 VGND VGND VPWR VPWR sky130_fd_sc_hd__fill_2
XFILLER_16_601 VPWR VGND VPWR VGND sky130_ef_sc_hd__decap_12
XTAP_TAPCELL_ROW_87_1192 VGND VPWR sky130_fd_sc_hd__tapvpwrvgnd_1
XTAP_TAPCELL_ROW_41_676 VGND VPWR sky130_fd_sc_hd__tapvpwrvgnd_1
XTAP_TAPCELL_ROW_13_378 VGND VPWR sky130_fd_sc_hd__tapvpwrvgnd_1
XFILLER_11_383 VGND VGND VPWR VPWR sky130_fd_sc_hd__decap_8
XFILLER_7_57 VGND VGND VPWR VPWR sky130_fd_sc_hd__fill_1
X_3270_ lsu.current_store_addr\[19\] net805 net258 VGND VGND VPWR VPWR _0830_ sky130_fd_sc_hd__mux2_1
XFILLER_97_125 VPWR VGND VPWR VGND sky130_ef_sc_hd__decap_12
XFILLER_100_609 VGND VGND VPWR VPWR sky130_fd_sc_hd__fill_2
X_2221_ net167 net164 _1670_ net244 lsu.load_counter\[8\] VGND VGND VPWR VPWR _1698_
+ sky130_fd_sc_hd__o2111a_1
XFILLER_97_169 VPWR VGND VPWR VGND sky130_ef_sc_hd__decap_12
X_2152_ _1640_ _1641_ VGND VGND VPWR VPWR _1642_ sky130_fd_sc_hd__nor2_1
XFILLER_66_545 VGND VGND VPWR VPWR sky130_fd_sc_hd__fill_1
XFILLER_16_3 VGND VGND VPWR VPWR sky130_fd_sc_hd__decap_3
X_2083_ lsu.load_counter\[20\] _1568_ _1572_ lsu.load_counter\[21\] VGND VGND VPWR
+ VPWR _1573_ sky130_fd_sc_hd__o22a_1
XFILLER_66_589 VGND VGND VPWR VPWR sky130_fd_sc_hd__fill_1
XFILLER_66_578 VGND VGND VPWR VPWR sky130_fd_sc_hd__decap_4
XTAP_TAPCELL_ROW_49_765 VGND VPWR sky130_fd_sc_hd__tapvpwrvgnd_1
XFILLER_19_461 VGND VGND VPWR VPWR sky130_fd_sc_hd__decap_6
XFILLER_19_494 VGND VGND VPWR VPWR sky130_fd_sc_hd__decap_8
XFILLER_21_103 VGND VGND VPWR VPWR sky130_fd_sc_hd__decap_8
XFILLER_34_475 VGND VGND VPWR VPWR sky130_fd_sc_hd__fill_1
X_4724_ clknet_leaf_28_clk _0781_ VGND VGND VPWR VPWR net110 sky130_fd_sc_hd__dfxtp_1
XFILLER_21_147 VGND VGND VPWR VPWR sky130_fd_sc_hd__decap_4
X_2985_ net740 net330 net191 VGND VGND VPWR VPWR _0493_ sky130_fd_sc_hd__mux2_1
X_4655_ clknet_leaf_30_clk _0712_ _0011_ VGND VGND VPWR VPWR lsu.load_fifo.w_ptr\[3\]
+ sky130_fd_sc_hd__dfrtp_1
XPHY_EDGE_ROW_2_Left_109 VGND VGND VPWR VPWR sky130_fd_sc_hd__decap_3
Xinput60 load_data[21] VGND VGND VPWR VPWR net60 sky130_fd_sc_hd__clkbuf_1
X_4586_ clknet_leaf_22_clk _0643_ VGND VGND VPWR VPWR lsu.load_fifo.queue\[8\]\[2\]
+ sky130_fd_sc_hd__dfxtp_1
Xinput71 load_data[31] VGND VGND VPWR VPWR net71 sky130_fd_sc_hd__clkbuf_1
Xhold811 lsu.load_fifo.data_in\[18\] VGND VGND VPWR VPWR net1279 sky130_fd_sc_hd__dlygate4sd3_1
Xinput82 store_base_addr[11] VGND VGND VPWR VPWR net82 sky130_fd_sc_hd__clkbuf_1
Xhold800 acc.byte0\[3\] VGND VGND VPWR VPWR net1268 sky130_fd_sc_hd__dlygate4sd3_1
X_3606_ net430 VGND VGND VPWR VPWR _0170_ sky130_fd_sc_hd__inv_2
Xinput93 store_base_addr[21] VGND VGND VPWR VPWR net93 sky130_fd_sc_hd__clkbuf_1
Xhold844 lsu.load_counter\[9\] VGND VGND VPWR VPWR net1312 sky130_fd_sc_hd__dlygate4sd3_1
X_3537_ net437 VGND VGND VPWR VPWR _0101_ sky130_fd_sc_hd__inv_2
Xhold822 lsu.current_store_addr\[18\] VGND VGND VPWR VPWR net1290 sky130_fd_sc_hd__dlygate4sd3_1
Xhold833 lsu.current_store_addr\[21\] VGND VGND VPWR VPWR net1301 sky130_fd_sc_hd__dlygate4sd3_1
XFILLER_103_447 VGND VGND VPWR VPWR sky130_fd_sc_hd__fill_1
X_3468_ net428 VGND VGND VPWR VPWR _0032_ sky130_fd_sc_hd__inv_2
XFILLER_88_147 VGND VGND VPWR VPWR sky130_fd_sc_hd__fill_1
X_2419_ lsu.current_store_addr\[18\] _1854_ VGND VGND VPWR VPWR _1855_ sky130_fd_sc_hd__and2_1
XFILLER_76_309 VGND VGND VPWR VPWR sky130_fd_sc_hd__decap_3
X_3399_ net768 net324 net200 VGND VGND VPWR VPWR _1049_ sky130_fd_sc_hd__mux2_1
XFILLER_29_225 VGND VGND VPWR VPWR sky130_fd_sc_hd__decap_6
XFILLER_16_22 VGND VGND VPWR VPWR sky130_fd_sc_hd__decap_6
XFILLER_13_615 VGND VGND VPWR VPWR sky130_fd_sc_hd__fill_1
XFILLER_40_401 VGND VGND VPWR VPWR sky130_fd_sc_hd__decap_8
XFILLER_12_136 VGND VGND VPWR VPWR sky130_fd_sc_hd__decap_4
XFILLER_32_21 VGND VGND VPWR VPWR sky130_fd_sc_hd__decap_6
XTAP_TAPCELL_ROW_10_337 VGND VPWR sky130_fd_sc_hd__tapvpwrvgnd_1
XFILLER_4_357 VGND VGND VPWR VPWR sky130_fd_sc_hd__decap_6
XFILLER_79_169 VGND VGND VPWR VPWR sky130_fd_sc_hd__decap_4
XFILLER_0_552 VGND VGND VPWR VPWR sky130_fd_sc_hd__decap_8
XFILLER_94_139 VGND VGND VPWR VPWR sky130_fd_sc_hd__fill_1
XTAP_TAPCELL_ROW_89_1210 VGND VPWR sky130_fd_sc_hd__tapvpwrvgnd_1
XFILLER_90_301 VGND VGND VPWR VPWR sky130_fd_sc_hd__decap_6
XTAP_TAPCELL_ROW_18_426 VGND VPWR sky130_fd_sc_hd__tapvpwrvgnd_1
XTAP_TAPCELL_ROW_46_735 VGND VPWR sky130_fd_sc_hd__tapvpwrvgnd_1
XFILLER_63_559 VGND VGND VPWR VPWR sky130_fd_sc_hd__fill_1
XFILLER_73_50 VGND VGND VPWR VPWR sky130_fd_sc_hd__decap_6
XFILLER_16_475 VGND VGND VPWR VPWR sky130_fd_sc_hd__fill_1
XFILLER_85_6 VPWR VGND VPWR VGND sky130_ef_sc_hd__decap_12
X_2770_ net1099 net272 _2028_ VGND VGND VPWR VPWR _0288_ sky130_fd_sc_hd__mux2_1
X_4440_ clknet_leaf_31_clk _0497_ VGND VGND VPWR VPWR lsu.load_fifo.queue\[4\]\[16\]
+ sky130_fd_sc_hd__dfxtp_1
Xhold107 lsu.store_fifo.queue\[5\]\[0\] VGND VGND VPWR VPWR net575 sky130_fd_sc_hd__dlygate4sd3_1
Xhold118 _0787_ VGND VGND VPWR VPWR net586 sky130_fd_sc_hd__dlygate4sd3_1
Xhold129 lsu.store_fifo.queue\[8\]\[1\] VGND VGND VPWR VPWR net597 sky130_fd_sc_hd__dlygate4sd3_1
X_4371_ clknet_leaf_86_clk _0428_ VGND VGND VPWR VPWR lsu.load_fifo.queue\[6\]\[11\]
+ sky130_fd_sc_hd__dfxtp_1
X_3322_ net621 net346 net175 VGND VGND VPWR VPWR _0932_ sky130_fd_sc_hd__mux2_1
X_3253_ lsu.current_store_addr\[2\] net691 net257 VGND VGND VPWR VPWR _0813_ sky130_fd_sc_hd__mux2_1
X_2204_ _1099_ _1674_ VGND VGND VPWR VPWR _1688_ sky130_fd_sc_hd__and2_1
X_3184_ net521 net330 net204 VGND VGND VPWR VPWR _0685_ sky130_fd_sc_hd__mux2_1
X_2135_ lsu.load_counter\[4\] _1622_ _1624_ lsu.load_counter\[5\] VGND VGND VPWR VPWR
+ _1625_ sky130_fd_sc_hd__o22ai_1
XFILLER_93_161 VGND VGND VPWR VPWR sky130_fd_sc_hd__decap_6
XFILLER_26_206 VGND VGND VPWR VPWR sky130_fd_sc_hd__decap_4
XFILLER_54_515 VPWR VGND VPWR VGND sky130_ef_sc_hd__decap_12
X_2066_ net18 net471 _1555_ VGND VGND VPWR VPWR _1556_ sky130_fd_sc_hd__or3_1
XTAP_TAPCELL_ROW_105_1387 VGND VPWR sky130_fd_sc_hd__tapvpwrvgnd_1
XFILLER_62_592 VGND VGND VPWR VPWR sky130_fd_sc_hd__decap_3
X_2968_ net294 net968 net216 VGND VGND VPWR VPWR _0479_ sky130_fd_sc_hd__mux2_1
X_4707_ clknet_leaf_45_clk _0764_ _0043_ VGND VGND VPWR VPWR lsu.storer_state\[1\]
+ sky130_fd_sc_hd__dfrtp_1
X_2899_ net604 net300 net194 VGND VGND VPWR VPWR _0410_ sky130_fd_sc_hd__mux2_1
X_4638_ clknet_leaf_72_clk _0695_ VGND VGND VPWR VPWR lsu.load_fifo.queue\[15\]\[22\]
+ sky130_fd_sc_hd__dfxtp_1
Xhold630 lsu.load_fifo.queue\[14\]\[11\] VGND VGND VPWR VPWR net1098 sky130_fd_sc_hd__dlygate4sd3_1
Xhold652 lsu.store_fifo.queue\[1\]\[9\] VGND VGND VPWR VPWR net1120 sky130_fd_sc_hd__dlygate4sd3_1
X_4569_ clknet_leaf_70_clk _0626_ VGND VGND VPWR VPWR lsu.load_fifo.queue\[0\]\[17\]
+ sky130_fd_sc_hd__dfxtp_1
Xhold663 lsu.store_fifo.queue\[9\]\[8\] VGND VGND VPWR VPWR net1131 sky130_fd_sc_hd__dlygate4sd3_1
Xhold641 lsu.store_fifo.queue\[4\]\[4\] VGND VGND VPWR VPWR net1109 sky130_fd_sc_hd__dlygate4sd3_1
XTAP_TAPCELL_ROW_73_1033 VGND VPWR sky130_fd_sc_hd__tapvpwrvgnd_1
Xhold674 lsu.load_fifo.queue\[6\]\[6\] VGND VGND VPWR VPWR net1142 sky130_fd_sc_hd__dlygate4sd3_1
Xhold696 lsu.store_fifo.queue\[1\]\[2\] VGND VGND VPWR VPWR net1164 sky130_fd_sc_hd__dlygate4sd3_1
Xhold685 lsu.store_fifo.queue\[13\]\[3\] VGND VGND VPWR VPWR net1153 sky130_fd_sc_hd__dlygate4sd3_1
XFILLER_94_27 VGND VGND VPWR VPWR sky130_fd_sc_hd__fill_1
XFILLER_84_150 VGND VGND VPWR VPWR sky130_fd_sc_hd__decap_4
XTAP_TAPCELL_ROW_84_1151 VGND VPWR sky130_fd_sc_hd__tapvpwrvgnd_1
XTAP_TAPCELL_ROW_43_705 VGND VPWR sky130_fd_sc_hd__tapvpwrvgnd_1
XFILLER_43_31 VGND VGND VPWR VPWR sky130_fd_sc_hd__decap_3
XFILLER_9_405 VPWR VGND VPWR VGND sky130_ef_sc_hd__decap_12
XFILLER_43_42 VGND VGND VPWR VPWR sky130_fd_sc_hd__decap_6
XFILLER_9_449 VPWR VGND VPWR VGND sky130_ef_sc_hd__decap_12
XTAP_TAPCELL_ROW_23_484 VGND VPWR sky130_fd_sc_hd__tapvpwrvgnd_1
XTAP_TAPCELL_ROW_51_793 VGND VPWR sky130_fd_sc_hd__tapvpwrvgnd_1
XTAP_TAPCELL_ROW_95_1280 VGND VPWR sky130_fd_sc_hd__tapvpwrvgnd_1
XFILLER_95_404 VGND VGND VPWR VPWR sky130_fd_sc_hd__fill_2
XFILLER_68_72 VGND VGND VPWR VPWR sky130_fd_sc_hd__fill_2
XFILLER_68_94 VGND VGND VPWR VPWR sky130_fd_sc_hd__fill_2
XFILLER_0_393 VPWR VGND VPWR VGND sky130_ef_sc_hd__decap_12
XFILLER_48_386 VPWR VGND VPWR VGND sky130_ef_sc_hd__decap_12
XTAP_TAPCELL_ROW_59_882 VGND VPWR sky130_fd_sc_hd__tapvpwrvgnd_1
X_3940_ lsu.load_fifo.queue\[4\]\[8\] lsu.load_fifo.queue\[5\]\[8\] lsu.load_fifo.queue\[6\]\[8\]
+ lsu.load_fifo.queue\[7\]\[8\] net398 net381 VGND VGND VPWR VPWR _1389_ sky130_fd_sc_hd__mux4_1
XFILLER_90_197 VGND VGND VPWR VPWR sky130_fd_sc_hd__decap_4
X_3871_ net1256 _1330_ net253 VGND VGND VPWR VPWR _1021_ sky130_fd_sc_hd__mux2_1
XTAP_TAPCELL_ROW_98_1309 VGND VPWR sky130_fd_sc_hd__tapvpwrvgnd_1
X_2822_ net323 net1162 net228 VGND VGND VPWR VPWR _0335_ sky130_fd_sc_hd__mux2_1
XFILLER_83_3 VGND VGND VPWR VPWR sky130_fd_sc_hd__decap_6
X_2753_ net284 net1052 _2027_ VGND VGND VPWR VPWR _0272_ sky130_fd_sc_hd__mux2_1
X_2684_ net883 net333 net230 VGND VGND VPWR VPWR _0208_ sky130_fd_sc_hd__mux2_1
X_4423_ clknet_leaf_79_clk _0480_ VGND VGND VPWR VPWR lsu.load_fifo.queue\[5\]\[31\]
+ sky130_fd_sc_hd__dfxtp_1
X_4354_ clknet_leaf_15_clk _0411_ VGND VGND VPWR VPWR lsu.load_fifo.queue\[7\]\[28\]
+ sky130_fd_sc_hd__dfxtp_1
XFILLER_98_253 VPWR VGND VPWR VGND sky130_ef_sc_hd__decap_12
Xfanout428 net429 VGND VGND VPWR VPWR net428 sky130_fd_sc_hd__buf_4
Xfanout417 lsu.load_fifo.w_ptr\[3\] VGND VGND VPWR VPWR net417 sky130_fd_sc_hd__clkbuf_2
Xfanout439 net445 VGND VGND VPWR VPWR net439 sky130_fd_sc_hd__buf_2
X_3305_ net314 net59 net248 VGND VGND VPWR VPWR _0867_ sky130_fd_sc_hd__mux2_1
Xfanout406 net408 VGND VGND VPWR VPWR net406 sky130_fd_sc_hd__clkbuf_4
XFILLER_86_448 VPWR VGND VPWR VGND sky130_ef_sc_hd__decap_12
X_4285_ clknet_leaf_80_clk _0342_ VGND VGND VPWR VPWR lsu.load_fifo.queue\[9\]\[23\]
+ sky130_fd_sc_hd__dfxtp_1
X_3236_ net561 lsu.current_load_addr\[8\] net237 VGND VGND VPWR VPWR _0774_ sky130_fd_sc_hd__mux2_1
XFILLER_104_26 VGND VGND VPWR VPWR sky130_fd_sc_hd__fill_2
X_3167_ net618 net299 net179 VGND VGND VPWR VPWR _0669_ sky130_fd_sc_hd__mux2_1
X_2118_ _1559_ _1605_ lsu.load_counter\[10\] VGND VGND VPWR VPWR _1608_ sky130_fd_sc_hd__a21o_1
X_3098_ net305 net1063 net186 VGND VGND VPWR VPWR _0602_ sky130_fd_sc_hd__mux2_1
XFILLER_80_29 VGND VGND VPWR VPWR sky130_fd_sc_hd__fill_2
XFILLER_22_286 VGND VGND VPWR VPWR sky130_fd_sc_hd__decap_6
XFILLER_50_573 VPWR VGND VPWR VGND sky130_ef_sc_hd__decap_12
XTAP_TAPCELL_ROW_20_454 VGND VPWR sky130_fd_sc_hd__tapvpwrvgnd_1
XFILLER_89_27 VPWR VGND VPWR VGND sky130_ef_sc_hd__decap_12
Xhold471 lsu.load_fifo.queue\[13\]\[11\] VGND VGND VPWR VPWR net939 sky130_fd_sc_hd__dlygate4sd3_1
XFILLER_1_113 VPWR VGND VPWR VGND sky130_ef_sc_hd__decap_12
XFILLER_2_625 VGND VGND VPWR VPWR sky130_fd_sc_hd__fill_2
Xhold460 lsu.load_fifo.queue\[2\]\[6\] VGND VGND VPWR VPWR net928 sky130_fd_sc_hd__dlygate4sd3_1
Xhold482 lsu.load_fifo.queue\[0\]\[21\] VGND VGND VPWR VPWR net950 sky130_fd_sc_hd__dlygate4sd3_1
Xhold493 lsu.load_fifo.queue\[11\]\[27\] VGND VGND VPWR VPWR net961 sky130_fd_sc_hd__dlygate4sd3_1
XFILLER_73_610 VGND VGND VPWR VPWR sky130_fd_sc_hd__fill_1
XFILLER_38_75 VGND VGND VPWR VPWR sky130_fd_sc_hd__fill_1
XFILLER_72_131 VGND VGND VPWR VPWR sky130_fd_sc_hd__fill_1
XTAP_TAPCELL_ROW_56_841 VGND VPWR sky130_fd_sc_hd__tapvpwrvgnd_1
XTAP_TAPCELL_ROW_28_543 VGND VPWR sky130_fd_sc_hd__tapvpwrvgnd_1
XFILLER_45_367 VGND VGND VPWR VPWR sky130_fd_sc_hd__fill_2
XFILLER_45_389 VGND VGND VPWR VPWR sky130_fd_sc_hd__decap_3
XFILLER_54_85 VGND VGND VPWR VPWR sky130_fd_sc_hd__decap_6
Xclkload16 clknet_leaf_85_clk VGND VGND VPWR VPWR clkload16/Y sky130_fd_sc_hd__clkinv_4
Xclkload38 clknet_leaf_24_clk VGND VGND VPWR VPWR clkload38/X sky130_fd_sc_hd__clkbuf_8
Xclkload27 clknet_leaf_80_clk VGND VGND VPWR VPWR clkload27/X sky130_fd_sc_hd__clkbuf_4
Xclkload49 clknet_leaf_33_clk VGND VGND VPWR VPWR clkload49/Y sky130_fd_sc_hd__clkinv_4
XFILLER_5_441 VGND VGND VPWR VPWR sky130_fd_sc_hd__decap_6
XFILLER_5_485 VPWR VGND VPWR VGND sky130_ef_sc_hd__decap_12
XFILLER_95_223 VGND VGND VPWR VPWR sky130_fd_sc_hd__fill_1
XFILLER_68_459 VGND VGND VPWR VPWR sky130_fd_sc_hd__fill_2
X_4070_ net401 _1502_ net404 VGND VGND VPWR VPWR _1505_ sky130_fd_sc_hd__o21ai_1
XFILLER_95_81 VPWR VGND VPWR VGND sky130_ef_sc_hd__decap_12
X_3021_ net880 net327 net210 VGND VGND VPWR VPWR _0527_ sky130_fd_sc_hd__mux2_1
XFILLER_64_610 VGND VGND VPWR VPWR sky130_fd_sc_hd__fill_1
X_4972_ clknet_leaf_73_clk _1027_ _0158_ VGND VGND VPWR VPWR acc.byte3\[1\] sky130_fd_sc_hd__dfrtp_1
X_3923_ _1374_ _1373_ net360 VGND VGND VPWR VPWR _1375_ sky130_fd_sc_hd__mux2_1
XTAP_TAPCELL_ROW_102_1357 VGND VPWR sky130_fd_sc_hd__tapvpwrvgnd_1
X_3854_ lsu.load_fifo.queue\[12\]\[21\] lsu.load_fifo.queue\[13\]\[21\] lsu.load_fifo.queue\[14\]\[21\]
+ lsu.load_fifo.queue\[15\]\[21\] net394 net377 VGND VGND VPWR VPWR _1316_ sky130_fd_sc_hd__mux4_1
X_2805_ net419 lsu.load_fifo.w_ptr\[1\] _1997_ net417 VGND VGND VPWR VPWR _2033_ sky130_fd_sc_hd__or4b_4
X_3785_ net380 lsu.load_fifo.w_ptr\[1\] VGND VGND VPWR VPWR _1257_ sky130_fd_sc_hd__xnor2_1
X_2736_ net274 net1095 net234 VGND VGND VPWR VPWR _0257_ sky130_fd_sc_hd__mux2_1
X_2667_ net765 net280 _2021_ VGND VGND VPWR VPWR _0192_ sky130_fd_sc_hd__mux2_1
X_4406_ clknet_leaf_3_clk _0463_ VGND VGND VPWR VPWR lsu.load_fifo.queue\[5\]\[14\]
+ sky130_fd_sc_hd__dfxtp_1
X_2598_ lsu.current_load_addr\[3\] _1985_ net476 VGND VGND VPWR VPWR _0730_ sky130_fd_sc_hd__mux2_4
XTAP_TAPCELL_ROW_70_1003 VGND VPWR sky130_fd_sc_hd__tapvpwrvgnd_1
Xfanout203 _2047_ VGND VGND VPWR VPWR net203 sky130_fd_sc_hd__clkbuf_4
Xfanout214 _2037_ VGND VGND VPWR VPWR net214 sky130_fd_sc_hd__buf_4
XFILLER_99_595 VPWR VGND VPWR VGND sky130_ef_sc_hd__decap_12
Xfanout225 _2035_ VGND VGND VPWR VPWR net225 sky130_fd_sc_hd__buf_2
X_4337_ clknet_leaf_86_clk _0394_ VGND VGND VPWR VPWR lsu.load_fifo.queue\[7\]\[11\]
+ sky130_fd_sc_hd__dfxtp_1
Xfanout247 _1447_ VGND VGND VPWR VPWR net247 sky130_fd_sc_hd__clkbuf_4
Xfanout258 _2052_ VGND VGND VPWR VPWR net258 sky130_fd_sc_hd__clkbuf_4
Xfanout269 _1718_ VGND VGND VPWR VPWR net269 sky130_fd_sc_hd__clkbuf_4
X_4268_ clknet_leaf_1_clk _0325_ VGND VGND VPWR VPWR lsu.load_fifo.queue\[9\]\[6\]
+ sky130_fd_sc_hd__dfxtp_1
XFILLER_101_578 VPWR VGND VPWR VGND sky130_ef_sc_hd__decap_12
XFILLER_86_278 VGND VGND VPWR VPWR sky130_fd_sc_hd__decap_4
X_3219_ net662 net287 _2050_ VGND VGND VPWR VPWR _0755_ sky130_fd_sc_hd__mux2_1
X_4199_ clknet_leaf_70_clk _0256_ VGND VGND VPWR VPWR lsu.store_fifo.queue\[7\]\[7\]
+ sky130_fd_sc_hd__dfxtp_1
XFILLER_91_39 VPWR VGND VPWR VGND sky130_ef_sc_hd__decap_12
XFILLER_15_529 VPWR VGND VPWR VGND sky130_ef_sc_hd__decap_12
XTAP_TAPCELL_ROW_25_502 VGND VPWR sky130_fd_sc_hd__tapvpwrvgnd_1
XTAP_TAPCELL_ROW_53_811 VGND VPWR sky130_fd_sc_hd__tapvpwrvgnd_1
XFILLER_54_197 VGND VGND VPWR VPWR sky130_fd_sc_hd__decap_3
XTAP_TAPCELL_ROW_81_1121 VGND VPWR sky130_fd_sc_hd__tapvpwrvgnd_1
XTAP_TAPCELL_ROW_33_590 VGND VPWR sky130_fd_sc_hd__tapvpwrvgnd_1
XTAP_TAPCELL_ROW_79_1094 VGND VPWR sky130_fd_sc_hd__tapvpwrvgnd_1
XFILLER_40_98 VPWR VGND VPWR VGND sky130_ef_sc_hd__decap_12
XFILLER_2_433 VPWR VGND VPWR VGND sky130_ef_sc_hd__decap_12
Xhold290 lsu.load_fifo.queue\[14\]\[0\] VGND VGND VPWR VPWR net758 sky130_fd_sc_hd__dlygate4sd3_1
XFILLER_2_477 VPWR VGND VPWR VGND sky130_ef_sc_hd__decap_12
XTAP_TAPCELL_ROW_5_282 VGND VPWR sky130_fd_sc_hd__tapvpwrvgnd_1
XFILLER_1_15 VPWR VGND VPWR VGND sky130_ef_sc_hd__decap_12
XFILLER_18_301 VGND VGND VPWR VPWR sky130_fd_sc_hd__decap_6
XFILLER_37_109 VGND VGND VPWR VPWR sky130_fd_sc_hd__decap_3
XFILLER_65_73 VGND VGND VPWR VPWR sky130_fd_sc_hd__fill_2
XFILLER_73_473 VPWR VGND VPWR VGND sky130_ef_sc_hd__decap_12
XFILLER_45_164 VGND VGND VPWR VPWR sky130_fd_sc_hd__decap_4
XFILLER_60_178 VGND VGND VPWR VPWR sky130_fd_sc_hd__fill_1
X_3570_ net422 VGND VGND VPWR VPWR _0134_ sky130_fd_sc_hd__inv_2
X_2521_ lsu.current_load_addr\[12\] _1926_ VGND VGND VPWR VPWR _1927_ sky130_fd_sc_hd__and2_1
XFILLER_102_309 VGND VGND VPWR VPWR sky130_fd_sc_hd__fill_1
X_2452_ lsu.current_store_addr\[13\] _1879_ net238 VGND VGND VPWR VPWR _0802_ sky130_fd_sc_hd__mux2_1
X_2383_ lsu.store_counter\[15\] _1586_ _1820_ _1821_ VGND VGND VPWR VPWR _1822_ sky130_fd_sc_hd__o211ai_1
XPHY_EDGE_ROW_18_Right_18 VGND VGND VPWR VPWR sky130_fd_sc_hd__decap_3
X_4122_ clknet_leaf_60_clk _0179_ VGND VGND VPWR VPWR lsu.store_fifo.queue\[11\]\[2\]
+ sky130_fd_sc_hd__dfxtp_1
X_4053_ net400 _1488_ VGND VGND VPWR VPWR _1489_ sky130_fd_sc_hd__nor2_1
XFILLER_56_429 VGND VGND VPWR VPWR sky130_fd_sc_hd__fill_2
Xinput3 count[10] VGND VGND VPWR VPWR net3 sky130_fd_sc_hd__buf_1
X_3004_ net532 net292 net190 VGND VGND VPWR VPWR _0512_ sky130_fd_sc_hd__mux2_1
XFILLER_83_259 VGND VGND VPWR VPWR sky130_fd_sc_hd__decap_4
XTAP_TAPCELL_ROW_67_969 VGND VPWR sky130_fd_sc_hd__tapvpwrvgnd_1
XFILLER_91_281 VPWR VGND VPWR VGND sky130_ef_sc_hd__decap_12
XPHY_EDGE_ROW_27_Right_27 VGND VGND VPWR VPWR sky130_fd_sc_hd__decap_3
XFILLER_36_197 VGND VGND VPWR VPWR sky130_fd_sc_hd__decap_4
X_4955_ clknet_leaf_55_clk _1010_ _0141_ VGND VGND VPWR VPWR acc.byte1\[0\] sky130_fd_sc_hd__dfrtp_1
X_3906_ _1358_ _1359_ net360 VGND VGND VPWR VPWR _1360_ sky130_fd_sc_hd__mux2_1
XFILLER_51_167 VGND VGND VPWR VPWR sky130_fd_sc_hd__fill_1
XFILLER_20_521 VGND VGND VPWR VPWR sky130_fd_sc_hd__decap_8
X_4886_ clknet_leaf_3_clk _0941_ VGND VGND VPWR VPWR lsu.load_fifo.queue\[12\]\[13\]
+ sky130_fd_sc_hd__dfxtp_1
X_3837_ lsu.load_fifo.queue\[12\]\[23\] lsu.load_fifo.queue\[13\]\[23\] lsu.load_fifo.queue\[14\]\[23\]
+ lsu.load_fifo.queue\[15\]\[23\] net388 net371 VGND VGND VPWR VPWR _1301_ sky130_fd_sc_hd__mux4_1
XTAP_TAPCELL_ROW_30_560 VGND VPWR sky130_fd_sc_hd__tapvpwrvgnd_1
X_3768_ _1213_ _1214_ _1218_ VGND VGND VPWR VPWR _1242_ sky130_fd_sc_hd__and3_1
XFILLER_106_615 VGND VGND VPWR VPWR sky130_fd_sc_hd__fill_1
X_2719_ net597 net289 _2025_ VGND VGND VPWR VPWR _0240_ sky130_fd_sc_hd__mux2_1
X_3699_ _1175_ _1176_ VGND VGND VPWR VPWR _1181_ sky130_fd_sc_hd__xor2_1
XPHY_EDGE_ROW_36_Right_36 VGND VGND VPWR VPWR sky130_fd_sc_hd__decap_3
XFILLER_59_223 VGND VGND VPWR VPWR sky130_fd_sc_hd__fill_1
XFILLER_19_55 VGND VGND VPWR VPWR sky130_fd_sc_hd__fill_1
XFILLER_59_256 VGND VGND VPWR VPWR sky130_fd_sc_hd__decap_3
XTAP_TAPCELL_ROW_2_252 VGND VPWR sky130_fd_sc_hd__tapvpwrvgnd_1
XFILLER_70_421 VPWR VGND VPWR VGND sky130_ef_sc_hd__decap_12
XFILLER_70_410 VGND VGND VPWR VPWR sky130_fd_sc_hd__decap_8
XFILLER_15_326 VGND VGND VPWR VPWR sky130_fd_sc_hd__fill_1
XFILLER_35_21 VGND VGND VPWR VPWR sky130_fd_sc_hd__decap_3
XPHY_EDGE_ROW_45_Right_45 VGND VGND VPWR VPWR sky130_fd_sc_hd__decap_3
XFILLER_15_337 VGND VGND VPWR VPWR sky130_fd_sc_hd__decap_8
XFILLER_7_503 VGND VGND VPWR VPWR sky130_fd_sc_hd__fill_1
XFILLER_51_42 VPWR VGND VPWR VGND sky130_ef_sc_hd__decap_12
XPHY_EDGE_ROW_54_Right_54 VGND VGND VPWR VPWR sky130_fd_sc_hd__decap_3
XFILLER_97_329 VGND VGND VPWR VPWR sky130_fd_sc_hd__decap_6
XFILLER_93_513 VGND VGND VPWR VPWR sky130_fd_sc_hd__decap_8
XFILLER_78_587 VGND VGND VPWR VPWR sky130_fd_sc_hd__fill_1
XFILLER_76_94 VGND VGND VPWR VPWR sky130_fd_sc_hd__fill_2
XFILLER_93_568 VGND VGND VPWR VPWR sky130_fd_sc_hd__fill_1
XFILLER_93_557 VGND VGND VPWR VPWR sky130_fd_sc_hd__decap_3
XPHY_EDGE_ROW_63_Right_63 VGND VGND VPWR VPWR sky130_fd_sc_hd__decap_3
XTAP_TAPCELL_ROW_64_939 VGND VPWR sky130_fd_sc_hd__tapvpwrvgnd_1
XFILLER_61_443 VGND VGND VPWR VPWR sky130_fd_sc_hd__decap_4
XFILLER_33_189 VGND VGND VPWR VPWR sky130_fd_sc_hd__decap_4
X_4740_ clknet_leaf_62_clk _0797_ _0054_ VGND VGND VPWR VPWR lsu.current_store_addr\[8\]
+ sky130_fd_sc_hd__dfrtp_1
X_4671_ clknet_leaf_28_clk _0728_ _0017_ VGND VGND VPWR VPWR lsu.current_load_addr\[1\]
+ sky130_fd_sc_hd__dfrtp_1
X_3622_ lsu.load_counter\[4\] VGND VGND VPWR VPWR _1105_ sky130_fd_sc_hd__inv_2
XPHY_EDGE_ROW_72_Right_72 VGND VGND VPWR VPWR sky130_fd_sc_hd__decap_3
X_3553_ net443 VGND VGND VPWR VPWR _0117_ sky130_fd_sc_hd__inv_2
X_2504_ _1913_ _1912_ _1914_ _1911_ VGND VGND VPWR VPWR _0763_ sky130_fd_sc_hd__a31o_1
X_3484_ net441 VGND VGND VPWR VPWR _0048_ sky130_fd_sc_hd__inv_2
X_2435_ lsu.current_store_addr\[16\] _1853_ lsu.current_store_addr\[17\] VGND VGND
+ VPWR VPWR _1867_ sky130_fd_sc_hd__a21oi_1
XFILLER_69_543 VPWR VGND VPWR VGND sky130_ef_sc_hd__decap_12
X_2366_ lsu.store_counter\[4\] _1622_ _1624_ lsu.store_counter\[5\] VGND VGND VPWR
+ VPWR _1805_ sky130_fd_sc_hd__o22ai_1
X_4105_ net246 _1536_ VGND VGND VPWR VPWR _1537_ sky130_fd_sc_hd__nand2_1
XPHY_EDGE_ROW_81_Right_81 VGND VGND VPWR VPWR sky130_fd_sc_hd__decap_3
X_2297_ net266 _1730_ net240 VGND VGND VPWR VPWR _1752_ sky130_fd_sc_hd__o21ai_1
X_4036_ net270 _1473_ VGND VGND VPWR VPWR _1474_ sky130_fd_sc_hd__nor2_1
XFILLER_52_421 VGND VGND VPWR VPWR sky130_fd_sc_hd__fill_2
X_4938_ clknet_leaf_64_clk _0993_ _0124_ VGND VGND VPWR VPWR net150 sky130_fd_sc_hd__dfrtp_1
X_4869_ clknet_leaf_42_clk _0924_ _0119_ VGND VGND VPWR VPWR lsu.load_counter\[19\]
+ sky130_fd_sc_hd__dfrtp_1
XPHY_EDGE_ROW_90_Right_90 VGND VGND VPWR VPWR sky130_fd_sc_hd__decap_3
XFILLER_97_27 VPWR VGND VPWR VGND sky130_ef_sc_hd__decap_12
XTAP_TAPCELL_ROW_76_1064 VGND VPWR sky130_fd_sc_hd__tapvpwrvgnd_1
XFILLER_79_329 VGND VGND VPWR VPWR sky130_fd_sc_hd__fill_1
XTAP_TAPCELL_ROW_7_311 VGND VPWR sky130_fd_sc_hd__tapvpwrvgnd_1
XFILLER_87_373 VPWR VGND VPWR VGND sky130_ef_sc_hd__decap_12
XFILLER_47_237 VGND VGND VPWR VPWR sky130_fd_sc_hd__decap_8
XFILLER_16_613 VPWR VGND VPWR VGND sky130_ef_sc_hd__decap_12
XTAP_TAPCELL_ROW_87_1182 VGND VPWR sky130_fd_sc_hd__tapvpwrvgnd_1
XFILLER_83_590 VGND VGND VPWR VPWR sky130_fd_sc_hd__fill_1
XFILLER_15_189 VGND VGND VPWR VPWR sky130_fd_sc_hd__fill_1
XFILLER_62_85 VGND VGND VPWR VPWR sky130_fd_sc_hd__decap_3
XTAP_TAPCELL_ROW_13_368 VGND VPWR sky130_fd_sc_hd__tapvpwrvgnd_1
XFILLER_7_300 VPWR VGND VPWR VGND sky130_ef_sc_hd__decap_12
XFILLER_7_36 VGND VGND VPWR VPWR sky130_fd_sc_hd__fill_2
XTAP_TAPCELL_ROW_41_677 VGND VPWR sky130_fd_sc_hd__tapvpwrvgnd_1
XFILLER_3_561 VPWR VGND VPWR VGND sky130_ef_sc_hd__decap_12
X_2220_ _1102_ _1696_ _1697_ net160 VGND VGND VPWR VPWR _0915_ sky130_fd_sc_hd__a2bb2o_4
XFILLER_97_137 VPWR VGND VPWR VGND sky130_ef_sc_hd__decap_12
X_2151_ lsu.load_counter\[0\] net2 _1639_ lsu.load_counter\[1\] VGND VGND VPWR VPWR
+ _1641_ sky130_fd_sc_hd__a22o_1
XFILLER_78_384 VPWR VGND VPWR VGND sky130_ef_sc_hd__decap_12
X_2082_ net15 _1567_ VGND VGND VPWR VPWR _1572_ sky130_fd_sc_hd__xor2_1
XFILLER_81_505 VPWR VGND VPWR VGND sky130_ef_sc_hd__decap_12
XTAP_TAPCELL_ROW_49_766 VGND VPWR sky130_fd_sc_hd__tapvpwrvgnd_1
X_2984_ net810 net332 net189 VGND VGND VPWR VPWR _0492_ sky130_fd_sc_hd__mux2_1
X_4723_ clknet_leaf_28_clk net954 VGND VGND VPWR VPWR net109 sky130_fd_sc_hd__dfxtp_1
X_4654_ clknet_leaf_37_clk _0711_ _0010_ VGND VGND VPWR VPWR lsu.load_fifo.w_ptr\[2\]
+ sky130_fd_sc_hd__dfrtp_1
Xhold812 lsu.load_fifo.data_in\[7\] VGND VGND VPWR VPWR net1280 sky130_fd_sc_hd__dlygate4sd3_1
Xinput72 load_data[3] VGND VGND VPWR VPWR net72 sky130_fd_sc_hd__clkbuf_1
Xinput61 load_data[22] VGND VGND VPWR VPWR net61 sky130_fd_sc_hd__clkbuf_1
X_4585_ clknet_leaf_78_clk _0642_ VGND VGND VPWR VPWR lsu.load_fifo.queue\[8\]\[1\]
+ sky130_fd_sc_hd__dfxtp_1
Xhold801 acc.byte1\[6\] VGND VGND VPWR VPWR net1269 sky130_fd_sc_hd__dlygate4sd3_1
X_3605_ net430 VGND VGND VPWR VPWR _0169_ sky130_fd_sc_hd__inv_2
Xinput50 load_data[12] VGND VGND VPWR VPWR net50 sky130_fd_sc_hd__clkbuf_1
Xhold834 lsu.load_counter\[21\] VGND VGND VPWR VPWR net1302 sky130_fd_sc_hd__dlygate4sd3_1
X_3536_ net437 VGND VGND VPWR VPWR _0100_ sky130_fd_sc_hd__inv_2
Xinput83 store_base_addr[12] VGND VGND VPWR VPWR net83 sky130_fd_sc_hd__clkbuf_1
Xinput94 store_base_addr[2] VGND VGND VPWR VPWR net94 sky130_fd_sc_hd__clkbuf_1
Xhold823 lsu.store_fifo.r_en VGND VGND VPWR VPWR net1291 sky130_fd_sc_hd__dlygate4sd3_1
Xhold845 lsu.current_store_addr\[4\] VGND VGND VPWR VPWR net1313 sky130_fd_sc_hd__dlygate4sd3_1
X_3467_ net426 VGND VGND VPWR VPWR _0031_ sky130_fd_sc_hd__inv_2
X_2418_ lsu.current_store_addr\[17\] lsu.current_store_addr\[16\] _1853_ VGND VGND
+ VPWR VPWR _1854_ sky130_fd_sc_hd__and3_1
X_3398_ net1107 net326 net198 VGND VGND VPWR VPWR _1048_ sky130_fd_sc_hd__mux2_1
X_2349_ lsu.store_counter\[15\] _1586_ VGND VGND VPWR VPWR _1788_ sky130_fd_sc_hd__xnor2_1
XFILLER_84_365 VPWR VGND VPWR VGND sky130_ef_sc_hd__decap_12
XFILLER_83_18 VGND VGND VPWR VPWR sky130_fd_sc_hd__decap_6
X_4019_ lsu.store_fifo.queue\[0\]\[8\] lsu.store_fifo.queue\[1\]\[8\] lsu.store_fifo.queue\[2\]\[8\]
+ lsu.store_fifo.queue\[3\]\[8\] net415 net409 VGND VGND VPWR VPWR _1458_ sky130_fd_sc_hd__mux4_1
XFILLER_37_281 VGND VGND VPWR VPWR sky130_fd_sc_hd__fill_2
XPHY_EDGE_ROW_0_Right_0 VGND VGND VPWR VPWR sky130_fd_sc_hd__decap_3
XFILLER_12_126 VGND VGND VPWR VPWR sky130_fd_sc_hd__fill_1
XFILLER_25_487 VGND VGND VPWR VPWR sky130_fd_sc_hd__decap_4
XFILLER_9_609 VGND VGND VPWR VPWR sky130_fd_sc_hd__decap_6
XFILLER_40_446 VGND VGND VPWR VPWR sky130_fd_sc_hd__fill_2
XTAP_TAPCELL_ROW_10_338 VGND VPWR sky130_fd_sc_hd__tapvpwrvgnd_1
XFILLER_106_286 VGND VGND VPWR VPWR sky130_fd_sc_hd__decap_4
XFILLER_48_502 VGND VGND VPWR VPWR sky130_fd_sc_hd__fill_1
XTAP_TAPCELL_ROW_89_1211 VGND VPWR sky130_fd_sc_hd__tapvpwrvgnd_1
XFILLER_16_421 VPWR VGND VPWR VGND sky130_ef_sc_hd__decap_12
XTAP_TAPCELL_ROW_18_427 VGND VPWR sky130_fd_sc_hd__tapvpwrvgnd_1
XTAP_TAPCELL_ROW_46_736 VGND VPWR sky130_fd_sc_hd__tapvpwrvgnd_1
XFILLER_71_582 VGND VGND VPWR VPWR sky130_fd_sc_hd__fill_1
XFILLER_43_262 VGND VGND VPWR VPWR sky130_fd_sc_hd__decap_6
Xhold108 lsu.load_fifo.queue\[11\]\[9\] VGND VGND VPWR VPWR net576 sky130_fd_sc_hd__dlygate4sd3_1
X_4370_ clknet_leaf_21_clk _0427_ VGND VGND VPWR VPWR lsu.load_fifo.queue\[6\]\[10\]
+ sky130_fd_sc_hd__dfxtp_1
Xhold119 lsu.load_fifo.queue\[3\]\[8\] VGND VGND VPWR VPWR net587 sky130_fd_sc_hd__dlygate4sd3_1
X_3321_ net1198 net348 net173 VGND VGND VPWR VPWR _0931_ sky130_fd_sc_hd__mux2_1
X_3252_ lsu.current_store_addr\[1\] net793 net258 VGND VGND VPWR VPWR _0812_ sky130_fd_sc_hd__mux2_1
X_2203_ net167 net164 _1674_ net263 net245 VGND VGND VPWR VPWR _1687_ sky130_fd_sc_hd__o221a_1
X_3183_ net643 net332 net202 VGND VGND VPWR VPWR _0684_ sky130_fd_sc_hd__mux2_1
X_2134_ _1617_ _1623_ VGND VGND VPWR VPWR _1624_ sky130_fd_sc_hd__and2_1
XFILLER_54_527 VGND VGND VPWR VPWR sky130_fd_sc_hd__fill_1
X_2065_ net21 net20 net19 VGND VGND VPWR VPWR _1555_ sky130_fd_sc_hd__or3_4
XTAP_TAPCELL_ROW_105_1388 VGND VPWR sky130_fd_sc_hd__tapvpwrvgnd_1
X_2967_ net296 net990 net216 VGND VGND VPWR VPWR _0478_ sky130_fd_sc_hd__mux2_1
X_4706_ clknet_leaf_45_clk _0763_ _0042_ VGND VGND VPWR VPWR lsu.storer_state\[0\]
+ sky130_fd_sc_hd__dfrtp_2
X_2898_ net641 net303 net195 VGND VGND VPWR VPWR _0409_ sky130_fd_sc_hd__mux2_1
X_4637_ clknet_leaf_27_clk _0694_ VGND VGND VPWR VPWR lsu.load_fifo.queue\[15\]\[21\]
+ sky130_fd_sc_hd__dfxtp_1
Xhold620 lsu.load_fifo.queue\[9\]\[23\] VGND VGND VPWR VPWR net1088 sky130_fd_sc_hd__dlygate4sd3_1
Xhold653 lsu.load_fifo.queue\[13\]\[10\] VGND VGND VPWR VPWR net1121 sky130_fd_sc_hd__dlygate4sd3_1
X_4568_ clknet_leaf_32_clk _0625_ VGND VGND VPWR VPWR lsu.load_fifo.queue\[0\]\[16\]
+ sky130_fd_sc_hd__dfxtp_1
Xhold631 lsu.store_fifo.queue\[4\]\[9\] VGND VGND VPWR VPWR net1099 sky130_fd_sc_hd__dlygate4sd3_1
Xhold642 lsu.load_fifo.queue\[13\]\[15\] VGND VGND VPWR VPWR net1110 sky130_fd_sc_hd__dlygate4sd3_1
X_3519_ net436 VGND VGND VPWR VPWR _0083_ sky130_fd_sc_hd__inv_2
XTAP_TAPCELL_ROW_73_1034 VGND VPWR sky130_fd_sc_hd__tapvpwrvgnd_1
X_4499_ clknet_leaf_86_clk _0556_ VGND VGND VPWR VPWR lsu.load_fifo.queue\[2\]\[11\]
+ sky130_fd_sc_hd__dfxtp_1
Xhold686 lsu.load_fifo.queue\[5\]\[23\] VGND VGND VPWR VPWR net1154 sky130_fd_sc_hd__dlygate4sd3_1
Xhold697 lsu.load_fifo.queue\[14\]\[20\] VGND VGND VPWR VPWR net1165 sky130_fd_sc_hd__dlygate4sd3_1
Xhold664 lsu.load_fifo.queue\[9\]\[14\] VGND VGND VPWR VPWR net1132 sky130_fd_sc_hd__dlygate4sd3_1
Xhold675 lsu.load_fifo.queue\[9\]\[13\] VGND VGND VPWR VPWR net1143 sky130_fd_sc_hd__dlygate4sd3_1
XFILLER_89_457 VPWR VGND VPWR VGND sky130_ef_sc_hd__decap_12
XFILLER_103_278 VGND VGND VPWR VPWR sky130_fd_sc_hd__fill_2
XFILLER_57_321 VPWR VGND VPWR VGND sky130_ef_sc_hd__decap_12
XFILLER_57_365 VPWR VGND VPWR VGND sky130_ef_sc_hd__decap_12
XTAP_TAPCELL_ROW_84_1152 VGND VPWR sky130_fd_sc_hd__tapvpwrvgnd_1
XTAP_TAPCELL_ROW_43_706 VGND VPWR sky130_fd_sc_hd__tapvpwrvgnd_1
XFILLER_9_417 VPWR VGND VPWR VGND sky130_ef_sc_hd__decap_12
Xclkbuf_leaf_20_clk clknet_3_2__leaf_clk VGND VGND VPWR VPWR clknet_leaf_20_clk sky130_fd_sc_hd__clkbuf_8
XTAP_TAPCELL_ROW_23_485 VGND VPWR sky130_fd_sc_hd__tapvpwrvgnd_1
XTAP_TAPCELL_ROW_51_794 VGND VPWR sky130_fd_sc_hd__tapvpwrvgnd_1
XTAP_TAPCELL_ROW_95_1270 VGND VPWR sky130_fd_sc_hd__tapvpwrvgnd_1
XFILLER_4_15 VPWR VGND VPWR VGND sky130_ef_sc_hd__decap_12
XFILLER_68_40 VGND VGND VPWR VPWR sky130_fd_sc_hd__decap_3
Xclkbuf_leaf_87_clk clknet_3_0__leaf_clk VGND VGND VPWR VPWR clknet_leaf_87_clk sky130_fd_sc_hd__clkbuf_8
XFILLER_48_365 VGND VGND VPWR VPWR sky130_fd_sc_hd__decap_8
XTAP_TAPCELL_ROW_59_883 VGND VPWR sky130_fd_sc_hd__tapvpwrvgnd_1
XFILLER_48_398 VGND VGND VPWR VPWR sky130_fd_sc_hd__decap_4
XFILLER_63_324 VGND VGND VPWR VPWR sky130_fd_sc_hd__decap_4
XFILLER_63_357 VGND VGND VPWR VPWR sky130_fd_sc_hd__decap_8
XFILLER_63_368 VPWR VGND VPWR VGND sky130_ef_sc_hd__decap_12
X_3870_ _1327_ _1329_ _1326_ _1328_ net356 net362 VGND VGND VPWR VPWR _1330_ sky130_fd_sc_hd__mux4_1
XFILLER_31_265 VGND VGND VPWR VPWR sky130_fd_sc_hd__decap_3
X_2821_ net324 net1212 net229 VGND VGND VPWR VPWR _0334_ sky130_fd_sc_hd__mux2_1
XFILLER_31_298 VGND VGND VPWR VPWR sky130_fd_sc_hd__decap_4
X_2752_ net286 net1011 _2027_ VGND VGND VPWR VPWR _0271_ sky130_fd_sc_hd__mux2_1
Xclkbuf_leaf_11_clk clknet_3_3__leaf_clk VGND VGND VPWR VPWR clknet_leaf_11_clk sky130_fd_sc_hd__clkbuf_8
X_2683_ net642 net335 net232 VGND VGND VPWR VPWR _0207_ sky130_fd_sc_hd__mux2_1
X_4422_ clknet_leaf_12_clk _0479_ VGND VGND VPWR VPWR lsu.load_fifo.queue\[5\]\[30\]
+ sky130_fd_sc_hd__dfxtp_1
X_4353_ clknet_leaf_81_clk _0410_ VGND VGND VPWR VPWR lsu.load_fifo.queue\[7\]\[27\]
+ sky130_fd_sc_hd__dfxtp_1
XFILLER_98_265 VGND VGND VPWR VPWR sky130_fd_sc_hd__decap_4
Xfanout429 net446 VGND VGND VPWR VPWR net429 sky130_fd_sc_hd__buf_2
Xfanout418 net419 VGND VGND VPWR VPWR net418 sky130_fd_sc_hd__clkbuf_2
X_3304_ net1253 net57 net248 VGND VGND VPWR VPWR _0866_ sky130_fd_sc_hd__mux2_1
X_4284_ clknet_leaf_72_clk _0341_ VGND VGND VPWR VPWR lsu.load_fifo.queue\[9\]\[22\]
+ sky130_fd_sc_hd__dfxtp_1
Xfanout407 net408 VGND VGND VPWR VPWR net407 sky130_fd_sc_hd__clkbuf_4
X_3235_ net630 lsu.current_load_addr\[7\] net237 VGND VGND VPWR VPWR _0773_ sky130_fd_sc_hd__mux2_1
Xclkbuf_leaf_78_clk clknet_3_1__leaf_clk VGND VGND VPWR VPWR clknet_leaf_78_clk sky130_fd_sc_hd__clkbuf_8
XFILLER_104_49 VGND VGND VPWR VPWR sky130_fd_sc_hd__decap_3
X_3166_ net815 net301 net178 VGND VGND VPWR VPWR _0668_ sky130_fd_sc_hd__mux2_1
X_2117_ lsu.load_counter\[10\] _1559_ _1605_ VGND VGND VPWR VPWR _1607_ sky130_fd_sc_hd__and3_1
X_3097_ net306 net1147 net188 VGND VGND VPWR VPWR _0601_ sky130_fd_sc_hd__mux2_1
XFILLER_66_195 VGND VGND VPWR VPWR sky130_fd_sc_hd__fill_1
XFILLER_50_541 VGND VGND VPWR VPWR sky130_fd_sc_hd__decap_8
XFILLER_50_585 VGND VGND VPWR VPWR sky130_fd_sc_hd__decap_3
X_3999_ acc.byte0\[0\] _1439_ net256 VGND VGND VPWR VPWR _1002_ sky130_fd_sc_hd__mux2_1
XFILLER_13_57 VGND VGND VPWR VPWR sky130_fd_sc_hd__decap_6
XTAP_TAPCELL_ROW_20_455 VGND VPWR sky130_fd_sc_hd__tapvpwrvgnd_1
XFILLER_89_39 VPWR VGND VPWR VGND sky130_ef_sc_hd__decap_12
Xhold450 lsu.load_fifo.queue\[2\]\[24\] VGND VGND VPWR VPWR net918 sky130_fd_sc_hd__dlygate4sd3_1
XFILLER_8_6 VGND VGND VPWR VPWR sky130_fd_sc_hd__decap_6
XFILLER_1_125 VPWR VGND VPWR VGND sky130_ef_sc_hd__decap_12
XFILLER_1_103 VGND VGND VPWR VPWR sky130_fd_sc_hd__decap_8
Xhold461 lsu.store_fifo.queue\[4\]\[5\] VGND VGND VPWR VPWR net929 sky130_fd_sc_hd__dlygate4sd3_1
Xhold472 lsu.load_fifo.queue\[7\]\[5\] VGND VGND VPWR VPWR net940 sky130_fd_sc_hd__dlygate4sd3_1
XFILLER_77_405 VGND VGND VPWR VPWR sky130_fd_sc_hd__decap_6
Xhold483 lsu.store_fifo.queue\[11\]\[6\] VGND VGND VPWR VPWR net951 sky130_fd_sc_hd__dlygate4sd3_1
Xhold494 lsu.load_fifo.queue\[12\]\[17\] VGND VGND VPWR VPWR net962 sky130_fd_sc_hd__dlygate4sd3_1
Xclkbuf_leaf_69_clk clknet_3_4__leaf_clk VGND VGND VPWR VPWR clknet_leaf_69_clk sky130_fd_sc_hd__clkbuf_8
XTAP_TAPCELL_ROW_28_533 VGND VPWR sky130_fd_sc_hd__tapvpwrvgnd_1
XFILLER_45_335 VGND VGND VPWR VPWR sky130_fd_sc_hd__fill_1
XTAP_TAPCELL_ROW_56_842 VGND VPWR sky130_fd_sc_hd__tapvpwrvgnd_1
XFILLER_54_53 VGND VGND VPWR VPWR sky130_fd_sc_hd__fill_1
Xclkload17 clknet_leaf_86_clk VGND VGND VPWR VPWR clkload17/Y sky130_fd_sc_hd__inv_6
Xclkload39 clknet_leaf_25_clk VGND VGND VPWR VPWR clkload39/X sky130_fd_sc_hd__clkbuf_4
Xclkload28 clknet_leaf_82_clk VGND VGND VPWR VPWR clkload28/X sky130_fd_sc_hd__clkbuf_8
XFILLER_5_497 VGND VGND VPWR VPWR sky130_fd_sc_hd__decap_6
XFILLER_95_279 VGND VGND VPWR VPWR sky130_fd_sc_hd__fill_1
XFILLER_95_93 VPWR VGND VPWR VGND sky130_ef_sc_hd__decap_12
XFILLER_76_460 VPWR VGND VPWR VGND sky130_ef_sc_hd__decap_12
Xclkbuf_leaf_0_clk clknet_3_0__leaf_clk VGND VGND VPWR VPWR clknet_leaf_0_clk sky130_fd_sc_hd__clkbuf_8
X_3020_ net820 net329 net210 VGND VGND VPWR VPWR _0526_ sky130_fd_sc_hd__mux2_1
XFILLER_24_519 VGND VGND VPWR VPWR sky130_fd_sc_hd__fill_1
X_4971_ clknet_leaf_34_clk _1026_ _0157_ VGND VGND VPWR VPWR acc.byte3\[0\] sky130_fd_sc_hd__dfrtp_1
X_3922_ lsu.load_fifo.queue\[0\]\[11\] lsu.load_fifo.queue\[1\]\[11\] lsu.load_fifo.queue\[2\]\[11\]
+ lsu.load_fifo.queue\[3\]\[11\] net383 net366 VGND VGND VPWR VPWR _1374_ sky130_fd_sc_hd__mux4_1
XTAP_TAPCELL_ROW_102_1347 VGND VPWR sky130_fd_sc_hd__tapvpwrvgnd_1
X_3853_ lsu.load_fifo.queue\[0\]\[21\] lsu.load_fifo.queue\[1\]\[21\] lsu.load_fifo.queue\[2\]\[21\]
+ lsu.load_fifo.queue\[3\]\[21\] net394 net377 VGND VGND VPWR VPWR _1315_ sky130_fd_sc_hd__mux4_1
X_2804_ net272 net1120 _2032_ VGND VGND VPWR VPWR _0318_ sky130_fd_sc_hd__mux2_1
X_3784_ net396 lsu.load_fifo.w_ptr\[0\] VGND VGND VPWR VPWR _1256_ sky130_fd_sc_hd__xor2_1
X_2735_ net277 net1236 net234 VGND VGND VPWR VPWR _0256_ sky130_fd_sc_hd__mux2_1
X_2666_ net509 net282 _2021_ VGND VGND VPWR VPWR _0191_ sky130_fd_sc_hd__mux2_1
X_4405_ clknet_leaf_4_clk _0462_ VGND VGND VPWR VPWR lsu.load_fifo.queue\[5\]\[13\]
+ sky130_fd_sc_hd__dfxtp_1
X_2597_ net39 _1984_ net264 VGND VGND VPWR VPWR _1985_ sky130_fd_sc_hd__mux2_1
Xfanout204 _2047_ VGND VGND VPWR VPWR net204 sky130_fd_sc_hd__buf_4
X_4336_ clknet_leaf_24_clk _0393_ VGND VGND VPWR VPWR lsu.load_fifo.queue\[7\]\[10\]
+ sky130_fd_sc_hd__dfxtp_1
XTAP_TAPCELL_ROW_70_1004 VGND VPWR sky130_fd_sc_hd__tapvpwrvgnd_1
Xfanout215 _2037_ VGND VGND VPWR VPWR net215 sky130_fd_sc_hd__buf_2
Xfanout226 _2033_ VGND VGND VPWR VPWR net226 sky130_fd_sc_hd__buf_4
XFILLER_59_416 VGND VGND VPWR VPWR sky130_fd_sc_hd__decap_4
Xfanout259 net261 VGND VGND VPWR VPWR net259 sky130_fd_sc_hd__buf_2
Xfanout248 _2054_ VGND VGND VPWR VPWR net248 sky130_fd_sc_hd__buf_4
X_4267_ clknet_leaf_5_clk _0324_ VGND VGND VPWR VPWR lsu.load_fifo.queue\[9\]\[5\]
+ sky130_fd_sc_hd__dfxtp_1
X_3218_ net555 net289 _2050_ VGND VGND VPWR VPWR _0754_ sky130_fd_sc_hd__mux2_1
X_4198_ clknet_leaf_54_clk _0255_ VGND VGND VPWR VPWR lsu.store_fifo.queue\[7\]\[6\]
+ sky130_fd_sc_hd__dfxtp_1
X_3149_ net528 net335 net179 VGND VGND VPWR VPWR _0651_ sky130_fd_sc_hd__mux2_1
XTAP_TAPCELL_ROW_25_503 VGND VPWR sky130_fd_sc_hd__tapvpwrvgnd_1
XTAP_TAPCELL_ROW_53_812 VGND VPWR sky130_fd_sc_hd__tapvpwrvgnd_1
XTAP_TAPCELL_ROW_81_1122 VGND VPWR sky130_fd_sc_hd__tapvpwrvgnd_1
XFILLER_24_56 VGND VGND VPWR VPWR sky130_fd_sc_hd__fill_2
XTAP_TAPCELL_ROW_33_591 VGND VPWR sky130_fd_sc_hd__tapvpwrvgnd_1
XTAP_TAPCELL_ROW_79_1095 VGND VPWR sky130_fd_sc_hd__tapvpwrvgnd_1
XTAP_TAPCELL_ROW_92_1240 VGND VPWR sky130_fd_sc_hd__tapvpwrvgnd_1
XFILLER_6_3 VPWR VGND VPWR VGND sky130_ef_sc_hd__decap_12
XFILLER_2_445 VPWR VGND VPWR VGND sky130_ef_sc_hd__decap_12
Xhold280 net142 VGND VGND VPWR VPWR net748 sky130_fd_sc_hd__dlygate4sd3_1
XFILLER_2_489 VPWR VGND VPWR VGND sky130_ef_sc_hd__decap_12
Xhold291 lsu.load_fifo.queue\[2\]\[22\] VGND VGND VPWR VPWR net759 sky130_fd_sc_hd__dlygate4sd3_1
XFILLER_49_53 VGND VGND VPWR VPWR sky130_fd_sc_hd__decap_3
XFILLER_49_97 VPWR VGND VPWR VGND sky130_ef_sc_hd__decap_12
XFILLER_77_279 VGND VGND VPWR VPWR sky130_fd_sc_hd__fill_1
XFILLER_1_27 VPWR VGND VPWR VGND sky130_ef_sc_hd__decap_12
XFILLER_58_460 VGND VGND VPWR VPWR sky130_fd_sc_hd__decap_4
XTAP_TAPCELL_ROW_5_283 VGND VPWR sky130_fd_sc_hd__tapvpwrvgnd_1
XFILLER_73_485 VPWR VGND VPWR VGND sky130_ef_sc_hd__decap_12
XFILLER_65_96 VPWR VGND VPWR VGND sky130_ef_sc_hd__decap_12
XFILLER_81_40 VGND VGND VPWR VPWR sky130_fd_sc_hd__fill_1
X_2520_ lsu.current_load_addr\[11\] lsu.current_load_addr\[10\] _1925_ VGND VGND VPWR
+ VPWR _1926_ sky130_fd_sc_hd__and3_1
X_2451_ net84 _1878_ net269 VGND VGND VPWR VPWR _1879_ sky130_fd_sc_hd__mux2_1
X_2382_ lsu.store_counter\[15\] _1586_ _1790_ VGND VGND VPWR VPWR _1821_ sky130_fd_sc_hd__a21bo_1
XFILLER_39_3 VGND VGND VPWR VPWR sky130_fd_sc_hd__fill_2
X_4121_ clknet_leaf_65_clk _0178_ VGND VGND VPWR VPWR lsu.store_fifo.queue\[11\]\[1\]
+ sky130_fd_sc_hd__dfxtp_1
X_4052_ lsu.store_fifo.queue\[0\]\[5\] lsu.store_fifo.queue\[1\]\[5\] lsu.store_fifo.queue\[2\]\[5\]
+ lsu.store_fifo.queue\[3\]\[5\] net411 net406 VGND VGND VPWR VPWR _1488_ sky130_fd_sc_hd__mux4_1
XFILLER_56_419 VGND VGND VPWR VPWR sky130_fd_sc_hd__fill_1
Xinput4 count[11] VGND VGND VPWR VPWR net4 sky130_fd_sc_hd__clkbuf_1
X_3003_ net1093 net294 net191 VGND VGND VPWR VPWR _0511_ sky130_fd_sc_hd__mux2_1
XFILLER_91_293 VGND VGND VPWR VPWR sky130_fd_sc_hd__decap_4
XFILLER_51_113 VGND VGND VPWR VPWR sky130_fd_sc_hd__fill_2
X_4954_ clknet_leaf_33_clk _1009_ _0140_ VGND VGND VPWR VPWR acc.byte0\[7\] sky130_fd_sc_hd__dfrtp_1
X_3905_ lsu.load_fifo.queue\[12\]\[13\] lsu.load_fifo.queue\[13\]\[13\] lsu.load_fifo.queue\[14\]\[13\]
+ lsu.load_fifo.queue\[15\]\[13\] net385 net368 VGND VGND VPWR VPWR _1359_ sky130_fd_sc_hd__mux4_1
XFILLER_20_533 VGND VGND VPWR VPWR sky130_fd_sc_hd__decap_4
X_4885_ clknet_leaf_18_clk _0940_ VGND VGND VPWR VPWR lsu.load_fifo.queue\[12\]\[12\]
+ sky130_fd_sc_hd__dfxtp_1
X_3836_ lsu.load_fifo.queue\[8\]\[23\] lsu.load_fifo.queue\[9\]\[23\] lsu.load_fifo.queue\[10\]\[23\]
+ lsu.load_fifo.queue\[11\]\[23\] net387 net370 VGND VGND VPWR VPWR _1300_ sky130_fd_sc_hd__mux4_1
XFILLER_20_577 VGND VGND VPWR VPWR sky130_fd_sc_hd__decap_8
XTAP_TAPCELL_ROW_30_561 VGND VPWR sky130_fd_sc_hd__tapvpwrvgnd_1
X_3767_ net286 _1241_ _1125_ VGND VGND VPWR VPWR _1078_ sky130_fd_sc_hd__mux2_1
X_2718_ net540 net291 _2025_ VGND VGND VPWR VPWR _0239_ sky130_fd_sc_hd__mux2_1
XFILLER_10_25 VGND VGND VPWR VPWR sky130_fd_sc_hd__decap_3
X_3698_ _1178_ _1179_ VGND VGND VPWR VPWR _1180_ sky130_fd_sc_hd__and2b_1
X_2649_ _2013_ _2016_ VGND VGND VPWR VPWR _2019_ sky130_fd_sc_hd__or2_4
XFILLER_86_29 VPWR VGND VPWR VGND sky130_ef_sc_hd__decap_12
XFILLER_59_213 VGND VGND VPWR VPWR sky130_fd_sc_hd__fill_1
XFILLER_101_332 VGND VGND VPWR VPWR sky130_fd_sc_hd__decap_4
X_4319_ clknet_leaf_68_clk _0376_ VGND VGND VPWR VPWR lsu.load_fifo.queue\[10\]\[25\]
+ sky130_fd_sc_hd__dfxtp_1
XFILLER_19_23 VGND VGND VPWR VPWR sky130_fd_sc_hd__decap_3
XFILLER_59_279 VGND VGND VPWR VPWR sky130_fd_sc_hd__fill_1
XFILLER_74_238 VGND VGND VPWR VPWR sky130_fd_sc_hd__decap_4
XTAP_TAPCELL_ROW_2_253 VGND VPWR sky130_fd_sc_hd__tapvpwrvgnd_1
XTAP_TAPCELL_ROW_38_650 VGND VPWR sky130_fd_sc_hd__tapvpwrvgnd_1
XFILLER_70_433 VPWR VGND VPWR VGND sky130_ef_sc_hd__decap_12
XFILLER_35_66 VGND VGND VPWR VPWR sky130_fd_sc_hd__decap_4
XFILLER_70_477 VPWR VGND VPWR VGND sky130_ef_sc_hd__decap_12
XFILLER_42_157 VGND VGND VPWR VPWR sky130_fd_sc_hd__fill_2
XFILLER_42_179 VGND VGND VPWR VPWR sky130_fd_sc_hd__fill_1
XFILLER_51_54 VGND VGND VPWR VPWR sky130_fd_sc_hd__fill_2
XFILLER_7_559 VGND VGND VPWR VPWR sky130_fd_sc_hd__fill_1
XFILLER_78_533 VGND VGND VPWR VPWR sky130_fd_sc_hd__decap_4
XFILLER_93_503 VGND VGND VPWR VPWR sky130_fd_sc_hd__fill_1
XFILLER_38_419 VGND VGND VPWR VPWR sky130_fd_sc_hd__fill_1
XFILLER_65_249 VGND VGND VPWR VPWR sky130_fd_sc_hd__decap_4
XTAP_TAPCELL_ROW_64_929 VGND VPWR sky130_fd_sc_hd__tapvpwrvgnd_1
XFILLER_92_83 VGND VGND VPWR VPWR sky130_fd_sc_hd__fill_1
X_4670_ clknet_leaf_25_clk _0727_ _0016_ VGND VGND VPWR VPWR lsu.current_load_addr\[0\]
+ sky130_fd_sc_hd__dfrtp_4
X_3621_ lsu.load_counter\[6\] VGND VGND VPWR VPWR _1104_ sky130_fd_sc_hd__inv_2
X_3552_ net443 VGND VGND VPWR VPWR _0116_ sky130_fd_sc_hd__inv_2
X_2503_ lsu.storer_state\[1\] lsu.storer_state\[0\] lsu.storer_state\[2\] VGND VGND
+ VPWR VPWR _1914_ sky130_fd_sc_hd__o21ai_1
XFILLER_6_581 VGND VGND VPWR VPWR sky130_fd_sc_hd__decap_6
X_3483_ net441 VGND VGND VPWR VPWR _0047_ sky130_fd_sc_hd__inv_2
X_2434_ net1290 _1724_ _1865_ _1866_ VGND VGND VPWR VPWR _0807_ sky130_fd_sc_hd__a22o_1
X_2365_ lsu.store_counter\[5\] _1624_ VGND VGND VPWR VPWR _1804_ sky130_fd_sc_hd__nand2_1
XFILLER_96_341 VGND VGND VPWR VPWR sky130_fd_sc_hd__decap_3
XFILLER_69_555 VGND VGND VPWR VPWR sky130_fd_sc_hd__decap_4
XPHY_EDGE_ROW_16_Left_123 VGND VGND VPWR VPWR sky130_fd_sc_hd__decap_3
X_4104_ net403 _1529_ _1531_ _1534_ _1535_ VGND VGND VPWR VPWR _1536_ sky130_fd_sc_hd__o32a_1
XFILLER_96_385 VPWR VGND VPWR VGND sky130_ef_sc_hd__decap_12
XFILLER_84_547 VGND VGND VPWR VPWR sky130_fd_sc_hd__fill_1
X_2296_ _1749_ _1751_ VGND VGND VPWR VPWR _0893_ sky130_fd_sc_hd__and2_1
XFILLER_56_205 VGND VGND VPWR VPWR sky130_fd_sc_hd__fill_1
X_4035_ lsu.store_fifo.queue\[12\]\[7\] lsu.store_fifo.queue\[13\]\[7\] lsu.store_fifo.queue\[14\]\[7\]
+ lsu.store_fifo.queue\[15\]\[7\] net413 net408 VGND VGND VPWR VPWR _1473_ sky130_fd_sc_hd__mux4_1
XFILLER_25_603 VPWR VGND VPWR VGND sky130_ef_sc_hd__decap_12
XTAP_TAPCELL_ROW_35_620 VGND VPWR sky130_fd_sc_hd__tapvpwrvgnd_1
XFILLER_52_477 VGND VGND VPWR VPWR sky130_fd_sc_hd__decap_3
X_4937_ clknet_leaf_48_clk _0992_ _0123_ VGND VGND VPWR VPWR net149 sky130_fd_sc_hd__dfrtp_1
X_4868_ clknet_leaf_43_clk _0923_ _0118_ VGND VGND VPWR VPWR lsu.load_counter\[18\]
+ sky130_fd_sc_hd__dfrtp_2
XPHY_EDGE_ROW_25_Left_132 VGND VGND VPWR VPWR sky130_fd_sc_hd__decap_3
X_3819_ lsu.load_fifo.queue\[8\]\[26\] lsu.load_fifo.queue\[9\]\[26\] lsu.load_fifo.queue\[10\]\[26\]
+ lsu.load_fifo.queue\[11\]\[26\] net392 net375 VGND VGND VPWR VPWR _1286_ sky130_fd_sc_hd__mux4_1
X_4799_ clknet_leaf_82_clk _0856_ VGND VGND VPWR VPWR lsu.load_fifo.data_in\[9\] sky130_fd_sc_hd__dfxtp_1
XTAP_TAPCELL_ROW_76_1065 VGND VPWR sky130_fd_sc_hd__tapvpwrvgnd_1
XFILLER_97_39 VPWR VGND VPWR VGND sky130_ef_sc_hd__decap_12
XTAP_TAPCELL_ROW_7_312 VGND VPWR sky130_fd_sc_hd__tapvpwrvgnd_1
XPHY_EDGE_ROW_34_Left_141 VGND VGND VPWR VPWR sky130_fd_sc_hd__decap_3
XPHY_EDGE_ROW_102_Right_102 VGND VGND VPWR VPWR sky130_fd_sc_hd__decap_3
XFILLER_75_503 VGND VGND VPWR VPWR sky130_fd_sc_hd__fill_1
XFILLER_87_385 VGND VGND VPWR VPWR sky130_fd_sc_hd__decap_6
XFILLER_47_205 VPWR VGND VPWR VGND sky130_ef_sc_hd__decap_12
XFILLER_16_625 VGND VGND VPWR VPWR sky130_fd_sc_hd__decap_4
XTAP_TAPCELL_ROW_87_1183 VGND VPWR sky130_fd_sc_hd__tapvpwrvgnd_1
XFILLER_15_113 VGND VGND VPWR VPWR sky130_fd_sc_hd__decap_3
XFILLER_102_93 VGND VGND VPWR VPWR sky130_fd_sc_hd__fill_1
XPHY_EDGE_ROW_43_Left_150 VGND VGND VPWR VPWR sky130_fd_sc_hd__decap_3
XTAP_TAPCELL_ROW_13_369 VGND VPWR sky130_fd_sc_hd__tapvpwrvgnd_1
XFILLER_7_312 VPWR VGND VPWR VGND sky130_ef_sc_hd__decap_12
XFILLER_7_15 VGND VGND VPWR VPWR sky130_fd_sc_hd__decap_4
XTAP_TAPCELL_ROW_41_678 VGND VPWR sky130_fd_sc_hd__tapvpwrvgnd_1
XFILLER_97_105 VGND VGND VPWR VPWR sky130_fd_sc_hd__decap_6
XFILLER_3_573 VPWR VGND VPWR VGND sky130_ef_sc_hd__decap_12
XFILLER_105_490 VGND VGND VPWR VPWR sky130_fd_sc_hd__fill_1
XFILLER_97_149 VPWR VGND VPWR VGND sky130_ef_sc_hd__decap_12
XFILLER_66_503 VGND VGND VPWR VPWR sky130_fd_sc_hd__decap_8
X_2150_ lsu.load_counter\[1\] _1639_ VGND VGND VPWR VPWR _1640_ sky130_fd_sc_hd__nor2_1
XFILLER_78_396 VPWR VGND VPWR VGND sky130_ef_sc_hd__decap_12
XFILLER_38_227 VGND VGND VPWR VPWR sky130_fd_sc_hd__decap_4
X_2081_ net15 _1567_ VGND VGND VPWR VPWR _1571_ sky130_fd_sc_hd__nand2_1
XTAP_TAPCELL_ROW_49_767 VGND VPWR sky130_fd_sc_hd__tapvpwrvgnd_1
XFILLER_93_377 VGND VGND VPWR VPWR sky130_fd_sc_hd__fill_1
XFILLER_81_517 VGND VGND VPWR VPWR sky130_fd_sc_hd__decap_4
XFILLER_53_219 VGND VGND VPWR VPWR sky130_fd_sc_hd__decap_4
XFILLER_46_293 VGND VGND VPWR VPWR sky130_fd_sc_hd__fill_2
XFILLER_34_477 VGND VGND VPWR VPWR sky130_fd_sc_hd__fill_1
X_2983_ net539 net334 net191 VGND VGND VPWR VPWR _0491_ sky130_fd_sc_hd__mux2_1
X_4722_ clknet_leaf_25_clk _0779_ VGND VGND VPWR VPWR net108 sky130_fd_sc_hd__dfxtp_1
Xinput40 load_base_addr[4] VGND VGND VPWR VPWR net40 sky130_fd_sc_hd__clkbuf_1
X_4653_ clknet_leaf_36_clk _0710_ _0009_ VGND VGND VPWR VPWR lsu.load_fifo.w_ptr\[1\]
+ sky130_fd_sc_hd__dfrtp_4
X_4584_ clknet_leaf_35_clk _0641_ VGND VGND VPWR VPWR lsu.load_fifo.queue\[8\]\[0\]
+ sky130_fd_sc_hd__dfxtp_1
Xhold802 acc.byte3\[5\] VGND VGND VPWR VPWR net1270 sky130_fd_sc_hd__dlygate4sd3_1
Xinput62 load_data[23] VGND VGND VPWR VPWR net62 sky130_fd_sc_hd__clkbuf_1
Xinput51 load_data[13] VGND VGND VPWR VPWR net51 sky130_fd_sc_hd__clkbuf_1
X_3604_ net430 VGND VGND VPWR VPWR _0168_ sky130_fd_sc_hd__inv_2
Xinput73 load_data[4] VGND VGND VPWR VPWR net73 sky130_fd_sc_hd__clkbuf_1
Xhold835 lsu.current_load_addr\[18\] VGND VGND VPWR VPWR net1303 sky130_fd_sc_hd__dlygate4sd3_1
X_3535_ net435 VGND VGND VPWR VPWR _0099_ sky130_fd_sc_hd__inv_2
Xhold824 lsu.load_fifo.data_in\[28\] VGND VGND VPWR VPWR net1292 sky130_fd_sc_hd__dlygate4sd3_1
Xhold813 lsu.current_store_addr\[8\] VGND VGND VPWR VPWR net1281 sky130_fd_sc_hd__dlygate4sd3_1
Xinput84 store_base_addr[13] VGND VGND VPWR VPWR net84 sky130_fd_sc_hd__clkbuf_1
Xhold846 lsu.current_store_addr\[4\] VGND VGND VPWR VPWR net1314 sky130_fd_sc_hd__dlygate4sd3_1
Xinput95 store_base_addr[3] VGND VGND VPWR VPWR net95 sky130_fd_sc_hd__clkbuf_1
X_3466_ net426 VGND VGND VPWR VPWR _0030_ sky130_fd_sc_hd__inv_2
XFILLER_89_628 VGND VGND VPWR VPWR sky130_fd_sc_hd__fill_2
X_2417_ lsu.current_store_addr\[15\] _1852_ VGND VGND VPWR VPWR _1853_ sky130_fd_sc_hd__and2_1
X_3397_ net966 net328 net198 VGND VGND VPWR VPWR _1047_ sky130_fd_sc_hd__mux2_1
XFILLER_57_503 VGND VGND VPWR VPWR sky130_fd_sc_hd__fill_1
X_2348_ lsu.store_counter\[16\] _1576_ _1785_ _1784_ _1786_ VGND VGND VPWR VPWR _1787_
+ sky130_fd_sc_hd__a2111oi_4
X_2279_ _1741_ _1740_ lsu.store_counter\[20\] VGND VGND VPWR VPWR _0900_ sky130_fd_sc_hd__mux2_1
XFILLER_57_547 VGND VGND VPWR VPWR sky130_fd_sc_hd__decap_4
XFILLER_84_377 VGND VGND VPWR VPWR sky130_fd_sc_hd__decap_8
X_4018_ net1248 net246 _1457_ VGND VGND VPWR VPWR _1001_ sky130_fd_sc_hd__o21a_1
XFILLER_80_561 VGND VGND VPWR VPWR sky130_fd_sc_hd__fill_1
XFILLER_13_617 VPWR VGND VPWR VGND sky130_ef_sc_hd__decap_12
XTAP_TAPCELL_ROW_10_339 VGND VPWR sky130_fd_sc_hd__tapvpwrvgnd_1
XFILLER_102_460 VGND VGND VPWR VPWR sky130_fd_sc_hd__fill_1
XTAP_TAPCELL_ROW_89_1212 VGND VPWR sky130_fd_sc_hd__tapvpwrvgnd_1
XFILLER_0_587 VGND VGND VPWR VPWR sky130_fd_sc_hd__fill_1
XFILLER_48_536 VGND VGND VPWR VPWR sky130_fd_sc_hd__fill_1
XFILLER_16_433 VPWR VGND VPWR VGND sky130_ef_sc_hd__decap_12
XTAP_TAPCELL_ROW_18_428 VGND VPWR sky130_fd_sc_hd__tapvpwrvgnd_1
XTAP_TAPCELL_ROW_46_737 VGND VPWR sky130_fd_sc_hd__tapvpwrvgnd_1
XFILLER_71_561 VGND VGND VPWR VPWR sky130_fd_sc_hd__decap_3
XFILLER_16_477 VPWR VGND VPWR VGND sky130_ef_sc_hd__decap_12
XFILLER_31_436 VGND VGND VPWR VPWR sky130_fd_sc_hd__decap_3
XFILLER_31_447 VGND VGND VPWR VPWR sky130_fd_sc_hd__fill_1
Xhold109 lsu.load_fifo.queue\[0\]\[20\] VGND VGND VPWR VPWR net577 sky130_fd_sc_hd__dlygate4sd3_1
XFILLER_7_186 VGND VGND VPWR VPWR sky130_fd_sc_hd__decap_6
X_3320_ net550 net351 net175 VGND VGND VPWR VPWR _0930_ sky130_fd_sc_hd__mux2_1
XFILLER_3_381 VGND VGND VPWR VPWR sky130_fd_sc_hd__decap_8
X_3251_ lsu.current_store_addr\[0\] net717 net258 VGND VGND VPWR VPWR _0811_ sky130_fd_sc_hd__mux2_1
X_2202_ lsu.load_counter\[17\] _1686_ _1684_ VGND VGND VPWR VPWR _0922_ sky130_fd_sc_hd__o21ba_1
XFILLER_100_419 VGND VGND VPWR VPWR sky130_fd_sc_hd__fill_1
X_3182_ net544 net334 net204 VGND VGND VPWR VPWR _0683_ sky130_fd_sc_hd__mux2_1
XFILLER_21_3 VGND VGND VPWR VPWR sky130_fd_sc_hd__fill_2
XFILLER_39_503 VGND VGND VPWR VPWR sky130_fd_sc_hd__fill_1
X_2133_ net18 net472 net19 VGND VGND VPWR VPWR _1623_ sky130_fd_sc_hd__o21ai_1
XFILLER_39_558 VGND VGND VPWR VPWR sky130_fd_sc_hd__fill_2
X_2064_ net16 net17 net2 net13 VGND VGND VPWR VPWR _1554_ sky130_fd_sc_hd__or4_4
XFILLER_54_539 VGND VGND VPWR VPWR sky130_fd_sc_hd__fill_2
XTAP_TAPCELL_ROW_105_1389 VGND VPWR sky130_fd_sc_hd__tapvpwrvgnd_1
X_2966_ net298 net791 net216 VGND VGND VPWR VPWR _0477_ sky130_fd_sc_hd__mux2_1
X_2897_ net816 net305 net194 VGND VGND VPWR VPWR _0408_ sky130_fd_sc_hd__mux2_1
X_4705_ clknet_leaf_59_clk _0762_ VGND VGND VPWR VPWR lsu.store_fifo.queue\[14\]\[9\]
+ sky130_fd_sc_hd__dfxtp_1
X_4636_ clknet_leaf_84_clk _0693_ VGND VGND VPWR VPWR lsu.load_fifo.queue\[15\]\[20\]
+ sky130_fd_sc_hd__dfxtp_1
Xhold621 lsu.load_fifo.queue\[6\]\[1\] VGND VGND VPWR VPWR net1089 sky130_fd_sc_hd__dlygate4sd3_1
Xhold610 lsu.load_fifo.queue\[5\]\[19\] VGND VGND VPWR VPWR net1078 sky130_fd_sc_hd__dlygate4sd3_1
Xhold654 net130 VGND VGND VPWR VPWR net1122 sky130_fd_sc_hd__dlygate4sd3_1
Xhold632 lsu.load_fifo.queue\[7\]\[6\] VGND VGND VPWR VPWR net1100 sky130_fd_sc_hd__dlygate4sd3_1
Xhold643 lsu.load_fifo.queue\[5\]\[13\] VGND VGND VPWR VPWR net1111 sky130_fd_sc_hd__dlygate4sd3_1
X_4567_ clknet_leaf_11_clk _0624_ VGND VGND VPWR VPWR lsu.load_fifo.queue\[0\]\[15\]
+ sky130_fd_sc_hd__dfxtp_1
X_3518_ net436 VGND VGND VPWR VPWR _0082_ sky130_fd_sc_hd__inv_2
X_4498_ clknet_leaf_24_clk _0555_ VGND VGND VPWR VPWR lsu.load_fifo.queue\[2\]\[10\]
+ sky130_fd_sc_hd__dfxtp_1
XTAP_TAPCELL_ROW_73_1035 VGND VPWR sky130_fd_sc_hd__tapvpwrvgnd_1
Xhold665 lsu.load_fifo.queue\[5\]\[6\] VGND VGND VPWR VPWR net1133 sky130_fd_sc_hd__dlygate4sd3_1
Xhold687 lsu.load_fifo.queue\[1\]\[22\] VGND VGND VPWR VPWR net1155 sky130_fd_sc_hd__dlygate4sd3_1
Xhold676 lsu.load_fifo.queue\[1\]\[19\] VGND VGND VPWR VPWR net1144 sky130_fd_sc_hd__dlygate4sd3_1
XFILLER_89_469 VPWR VGND VPWR VGND sky130_ef_sc_hd__decap_12
Xhold698 lsu.load_fifo.queue\[13\]\[31\] VGND VGND VPWR VPWR net1166 sky130_fd_sc_hd__dlygate4sd3_1
X_3449_ net432 VGND VGND VPWR VPWR _0013_ sky130_fd_sc_hd__inv_2
XFILLER_57_311 VGND VGND VPWR VPWR sky130_fd_sc_hd__fill_1
XFILLER_97_491 VGND VGND VPWR VPWR sky130_fd_sc_hd__fill_1
XFILLER_94_29 VPWR VGND VPWR VGND sky130_ef_sc_hd__decap_12
XFILLER_57_333 VGND VGND VPWR VPWR sky130_fd_sc_hd__decap_3
XFILLER_57_377 VGND VGND VPWR VPWR sky130_fd_sc_hd__fill_2
XFILLER_72_369 VGND VGND VPWR VPWR sky130_fd_sc_hd__fill_2
XTAP_TAPCELL_ROW_43_707 VGND VPWR sky130_fd_sc_hd__tapvpwrvgnd_1
XTAP_TAPCELL_ROW_84_1153 VGND VPWR sky130_fd_sc_hd__tapvpwrvgnd_1
XFILLER_25_252 VGND VGND VPWR VPWR sky130_fd_sc_hd__fill_1
XFILLER_13_447 VGND VGND VPWR VPWR sky130_fd_sc_hd__fill_1
Xclone10 net168 VGND VGND VPWR VPWR net478 sky130_fd_sc_hd__clkbuf_2
XFILLER_9_429 VPWR VGND VPWR VGND sky130_ef_sc_hd__decap_12
XFILLER_43_66 VGND VGND VPWR VPWR sky130_fd_sc_hd__fill_2
XTAP_TAPCELL_ROW_23_486 VGND VPWR sky130_fd_sc_hd__tapvpwrvgnd_1
XTAP_TAPCELL_ROW_51_795 VGND VPWR sky130_fd_sc_hd__tapvpwrvgnd_1
XTAP_TAPCELL_ROW_95_1271 VGND VPWR sky130_fd_sc_hd__tapvpwrvgnd_1
XFILLER_4_27 VGND VGND VPWR VPWR sky130_fd_sc_hd__fill_1
XFILLER_95_428 VGND VGND VPWR VPWR sky130_fd_sc_hd__decap_3
XFILLER_102_290 VGND VGND VPWR VPWR sky130_fd_sc_hd__fill_1
XFILLER_48_355 VGND VGND VPWR VPWR sky130_fd_sc_hd__decap_8
XFILLER_48_377 VGND VGND VPWR VPWR sky130_fd_sc_hd__fill_2
XTAP_TAPCELL_ROW_59_884 VGND VPWR sky130_fd_sc_hd__tapvpwrvgnd_1
XFILLER_63_314 VGND VGND VPWR VPWR sky130_fd_sc_hd__fill_1
XFILLER_44_583 VGND VGND VPWR VPWR sky130_fd_sc_hd__fill_2
XFILLER_71_380 VGND VGND VPWR VPWR sky130_fd_sc_hd__decap_3
X_2820_ net327 net1132 net226 VGND VGND VPWR VPWR _0333_ sky130_fd_sc_hd__mux2_1
X_2751_ net288 net983 _2027_ VGND VGND VPWR VPWR _0270_ sky130_fd_sc_hd__mux2_1
X_2682_ net576 net337 net230 VGND VGND VPWR VPWR _0206_ sky130_fd_sc_hd__mux2_1
X_4421_ clknet_leaf_22_clk _0478_ VGND VGND VPWR VPWR lsu.load_fifo.queue\[5\]\[29\]
+ sky130_fd_sc_hd__dfxtp_1
XFILLER_98_200 VPWR VGND VPWR VGND sky130_ef_sc_hd__decap_12
X_4352_ clknet_leaf_6_clk _0409_ VGND VGND VPWR VPWR lsu.load_fifo.queue\[7\]\[26\]
+ sky130_fd_sc_hd__dfxtp_1
X_4283_ clknet_leaf_27_clk _0340_ VGND VGND VPWR VPWR lsu.load_fifo.queue\[9\]\[21\]
+ sky130_fd_sc_hd__dfxtp_1
XFILLER_86_406 VGND VGND VPWR VPWR sky130_fd_sc_hd__decap_4
Xfanout419 lsu.load_fifo.w_ptr\[2\] VGND VGND VPWR VPWR net419 sky130_fd_sc_hd__buf_2
X_3303_ net1279 net56 net248 VGND VGND VPWR VPWR _0865_ sky130_fd_sc_hd__mux2_1
Xfanout408 lsu.store_fifo.r_ptr\[1\] VGND VGND VPWR VPWR net408 sky130_fd_sc_hd__clkbuf_2
XFILLER_59_609 VGND VGND VPWR VPWR sky130_fd_sc_hd__fill_1
X_3234_ net563 lsu.current_load_addr\[6\] net237 VGND VGND VPWR VPWR _0772_ sky130_fd_sc_hd__mux2_1
XFILLER_94_461 VGND VGND VPWR VPWR sky130_fd_sc_hd__decap_6
X_3165_ net638 net302 net179 VGND VGND VPWR VPWR _0667_ sky130_fd_sc_hd__mux2_1
XFILLER_66_141 VGND VGND VPWR VPWR sky130_fd_sc_hd__fill_1
X_2116_ _1559_ _1605_ VGND VGND VPWR VPWR _1606_ sky130_fd_sc_hd__and2_1
X_3096_ net308 net1160 net186 VGND VGND VPWR VPWR _0600_ sky130_fd_sc_hd__mux2_1
XFILLER_39_399 VGND VGND VPWR VPWR sky130_fd_sc_hd__fill_2
XFILLER_54_358 VGND VGND VPWR VPWR sky130_fd_sc_hd__decap_6
XFILLER_50_520 VGND VGND VPWR VPWR sky130_fd_sc_hd__fill_1
X_3998_ _1436_ _1438_ _1435_ _1437_ net359 net363 VGND VGND VPWR VPWR _1439_ sky130_fd_sc_hd__mux4_1
X_2949_ net332 net1141 net214 VGND VGND VPWR VPWR _0460_ sky130_fd_sc_hd__mux2_1
XTAP_TAPCELL_ROW_20_445 VGND VPWR sky130_fd_sc_hd__tapvpwrvgnd_1
X_4619_ clknet_leaf_87_clk _0676_ VGND VGND VPWR VPWR lsu.load_fifo.queue\[15\]\[3\]
+ sky130_fd_sc_hd__dfxtp_1
Xhold440 lsu.load_fifo.queue\[14\]\[16\] VGND VGND VPWR VPWR net908 sky130_fd_sc_hd__dlygate4sd3_1
Xhold451 lsu.load_fifo.queue\[0\]\[16\] VGND VGND VPWR VPWR net919 sky130_fd_sc_hd__dlygate4sd3_1
Xhold462 lsu.load_fifo.queue\[2\]\[31\] VGND VGND VPWR VPWR net930 sky130_fd_sc_hd__dlygate4sd3_1
Xhold484 lsu.load_fifo.queue\[12\]\[21\] VGND VGND VPWR VPWR net952 sky130_fd_sc_hd__dlygate4sd3_1
Xhold495 lsu.load_fifo.queue\[6\]\[21\] VGND VGND VPWR VPWR net963 sky130_fd_sc_hd__dlygate4sd3_1
XPHY_EDGE_ROW_8_Left_115 VGND VGND VPWR VPWR sky130_fd_sc_hd__decap_3
XFILLER_1_137 VGND VGND VPWR VPWR sky130_fd_sc_hd__decap_6
Xhold473 lsu.store_fifo.queue\[15\]\[5\] VGND VGND VPWR VPWR net941 sky130_fd_sc_hd__dlygate4sd3_1
XFILLER_38_11 VGND VGND VPWR VPWR sky130_fd_sc_hd__fill_1
XFILLER_85_483 VPWR VGND VPWR VGND sky130_ef_sc_hd__decap_12
XFILLER_57_196 VGND VGND VPWR VPWR sky130_fd_sc_hd__decap_3
XFILLER_72_144 VGND VGND VPWR VPWR sky130_fd_sc_hd__fill_2
XTAP_TAPCELL_ROW_28_534 VGND VPWR sky130_fd_sc_hd__tapvpwrvgnd_1
XFILLER_54_21 VGND VGND VPWR VPWR sky130_fd_sc_hd__decap_6
XTAP_TAPCELL_ROW_56_843 VGND VPWR sky130_fd_sc_hd__tapvpwrvgnd_1
XTAP_TAPCELL_ROW_97_1300 VGND VPWR sky130_fd_sc_hd__tapvpwrvgnd_1
Xclkload29 clknet_leaf_83_clk VGND VGND VPWR VPWR clkload29/Y sky130_fd_sc_hd__clkinvlp_4
Xclkload18 clknet_leaf_8_clk VGND VGND VPWR VPWR clkload18/X sky130_fd_sc_hd__clkbuf_4
XFILLER_95_225 VPWR VGND VPWR VGND sky130_ef_sc_hd__decap_12
XFILLER_0_181 VGND VGND VPWR VPWR sky130_fd_sc_hd__decap_8
XFILLER_64_601 VGND VGND VPWR VPWR sky130_fd_sc_hd__fill_1
XFILLER_76_472 VGND VGND VPWR VPWR sky130_fd_sc_hd__decap_4
XFILLER_17_561 VPWR VGND VPWR VGND sky130_ef_sc_hd__decap_12
X_4970_ clknet_leaf_75_clk _1025_ _0156_ VGND VGND VPWR VPWR acc.byte2\[7\] sky130_fd_sc_hd__dfrtp_1
XFILLER_51_306 VGND VGND VPWR VPWR sky130_fd_sc_hd__decap_6
X_3921_ lsu.load_fifo.queue\[4\]\[11\] lsu.load_fifo.queue\[5\]\[11\] lsu.load_fifo.queue\[6\]\[11\]
+ lsu.load_fifo.queue\[7\]\[11\] net384 net367 VGND VGND VPWR VPWR _1373_ sky130_fd_sc_hd__mux4_1
XTAP_TAPCELL_ROW_102_1348 VGND VPWR sky130_fd_sc_hd__tapvpwrvgnd_1
X_3852_ lsu.load_fifo.queue\[4\]\[21\] lsu.load_fifo.queue\[5\]\[21\] lsu.load_fifo.queue\[6\]\[21\]
+ lsu.load_fifo.queue\[7\]\[21\] net394 net377 VGND VGND VPWR VPWR _1314_ sky130_fd_sc_hd__mux4_1
XFILLER_32_575 VGND VGND VPWR VPWR sky130_fd_sc_hd__fill_2
X_2803_ net275 net1181 _2032_ VGND VGND VPWR VPWR _0317_ sky130_fd_sc_hd__mux2_1
X_3783_ net363 net419 VGND VGND VPWR VPWR _1255_ sky130_fd_sc_hd__xor2_1
X_2734_ net279 net617 net234 VGND VGND VPWR VPWR _0255_ sky130_fd_sc_hd__mux2_1
X_2665_ net626 net284 _2021_ VGND VGND VPWR VPWR _0190_ sky130_fd_sc_hd__mux2_1
X_2596_ _1921_ _1983_ VGND VGND VPWR VPWR _1984_ sky130_fd_sc_hd__nor2_1
X_4404_ clknet_leaf_19_clk _0461_ VGND VGND VPWR VPWR lsu.load_fifo.queue\[5\]\[12\]
+ sky130_fd_sc_hd__dfxtp_1
Xfanout205 _2047_ VGND VGND VPWR VPWR net205 sky130_fd_sc_hd__buf_2
XFILLER_5_81 VPWR VGND VPWR VGND sky130_ef_sc_hd__decap_12
X_4335_ clknet_leaf_82_clk _0392_ VGND VGND VPWR VPWR lsu.load_fifo.queue\[7\]\[9\]
+ sky130_fd_sc_hd__dfxtp_1
Xfanout216 _2037_ VGND VGND VPWR VPWR net216 sky130_fd_sc_hd__buf_4
Xfanout238 _1723_ VGND VGND VPWR VPWR net238 sky130_fd_sc_hd__buf_2
XTAP_TAPCELL_ROW_70_1005 VGND VPWR sky130_fd_sc_hd__tapvpwrvgnd_1
Xfanout227 _2033_ VGND VGND VPWR VPWR net227 sky130_fd_sc_hd__clkbuf_4
XFILLER_101_558 VGND VGND VPWR VPWR sky130_fd_sc_hd__fill_2
Xfanout249 _2054_ VGND VGND VPWR VPWR net249 sky130_fd_sc_hd__clkbuf_2
X_4266_ clknet_leaf_17_clk _0323_ VGND VGND VPWR VPWR lsu.load_fifo.queue\[9\]\[4\]
+ sky130_fd_sc_hd__dfxtp_1
XFILLER_86_269 VGND VGND VPWR VPWR sky130_fd_sc_hd__fill_1
X_4197_ clknet_leaf_71_clk _0254_ VGND VGND VPWR VPWR lsu.store_fifo.queue\[7\]\[5\]
+ sky130_fd_sc_hd__dfxtp_1
XFILLER_55_601 VGND VGND VPWR VPWR sky130_fd_sc_hd__fill_1
X_3217_ net614 net291 _2050_ VGND VGND VPWR VPWR _0753_ sky130_fd_sc_hd__mux2_1
X_3148_ net622 net337 net177 VGND VGND VPWR VPWR _0650_ sky130_fd_sc_hd__mux2_1
XFILLER_54_100 VPWR VGND VPWR VGND sky130_ef_sc_hd__decap_12
XFILLER_82_475 VGND VGND VPWR VPWR sky130_fd_sc_hd__fill_1
X_3079_ net343 net1171 net185 VGND VGND VPWR VPWR _0583_ sky130_fd_sc_hd__mux2_1
XTAP_TAPCELL_ROW_25_504 VGND VPWR sky130_fd_sc_hd__tapvpwrvgnd_1
XTAP_TAPCELL_ROW_53_813 VGND VPWR sky130_fd_sc_hd__tapvpwrvgnd_1
XTAP_TAPCELL_ROW_81_1123 VGND VPWR sky130_fd_sc_hd__tapvpwrvgnd_1
XFILLER_35_391 VGND VGND VPWR VPWR sky130_fd_sc_hd__fill_1
XTAP_TAPCELL_ROW_33_592 VGND VPWR sky130_fd_sc_hd__tapvpwrvgnd_1
XTAP_TAPCELL_ROW_79_1096 VGND VPWR sky130_fd_sc_hd__tapvpwrvgnd_1
XTAP_TAPCELL_ROW_92_1241 VGND VPWR sky130_fd_sc_hd__tapvpwrvgnd_1
Xhold270 lsu.load_fifo.queue\[12\]\[7\] VGND VGND VPWR VPWR net738 sky130_fd_sc_hd__dlygate4sd3_1
XFILLER_2_457 VPWR VGND VPWR VGND sky130_ef_sc_hd__decap_12
Xhold292 lsu.load_fifo.queue\[4\]\[19\] VGND VGND VPWR VPWR net760 sky130_fd_sc_hd__dlygate4sd3_1
Xhold281 _0814_ VGND VGND VPWR VPWR net749 sky130_fd_sc_hd__dlygate4sd3_1
XFILLER_105_82 VGND VGND VPWR VPWR sky130_fd_sc_hd__fill_2
XTAP_TAPCELL_ROW_69_990 VGND VPWR sky130_fd_sc_hd__tapvpwrvgnd_1
XTAP_TAPCELL_ROW_5_284 VGND VPWR sky130_fd_sc_hd__tapvpwrvgnd_1
XFILLER_1_39 VPWR VGND VPWR VGND sky130_ef_sc_hd__decap_12
XFILLER_65_42 VGND VGND VPWR VPWR sky130_fd_sc_hd__decap_3
XFILLER_45_177 VGND VGND VPWR VPWR sky130_fd_sc_hd__fill_2
XFILLER_73_497 VGND VGND VPWR VPWR sky130_fd_sc_hd__decap_6
XFILLER_14_531 VGND VGND VPWR VPWR sky130_fd_sc_hd__fill_1
XFILLER_81_52 VGND VGND VPWR VPWR sky130_fd_sc_hd__decap_4
XFILLER_41_350 VGND VGND VPWR VPWR sky130_fd_sc_hd__decap_6
XFILLER_81_96 VGND VGND VPWR VPWR sky130_fd_sc_hd__decap_6
X_2450_ lsu.current_store_addr\[13\] _1851_ VGND VGND VPWR VPWR _1878_ sky130_fd_sc_hd__xor2_1
XFILLER_53_6 VGND VGND VPWR VPWR sky130_fd_sc_hd__fill_2
XFILLER_96_501 VGND VGND VPWR VPWR sky130_fd_sc_hd__decap_6
X_2381_ _1788_ _1791_ _1793_ VGND VGND VPWR VPWR _1820_ sky130_fd_sc_hd__or3_1
XFILLER_68_247 VGND VGND VPWR VPWR sky130_fd_sc_hd__decap_4
X_4120_ clknet_leaf_51_clk _0177_ VGND VGND VPWR VPWR lsu.store_fifo.queue\[11\]\[0\]
+ sky130_fd_sc_hd__dfxtp_1
XFILLER_96_589 VGND VGND VPWR VPWR sky130_fd_sc_hd__decap_6
X_4051_ net1245 net247 _1487_ VGND VGND VPWR VPWR _0998_ sky130_fd_sc_hd__o21a_1
Xinput5 count[12] VGND VGND VPWR VPWR net5 sky130_fd_sc_hd__clkbuf_2
X_3002_ net548 net296 net191 VGND VGND VPWR VPWR _0510_ sky130_fd_sc_hd__mux2_1
XFILLER_49_472 VGND VGND VPWR VPWR sky130_fd_sc_hd__fill_1
XFILLER_91_261 VPWR VGND VPWR VGND sky130_ef_sc_hd__decap_12
XFILLER_24_306 VGND VGND VPWR VPWR sky130_fd_sc_hd__fill_2
XFILLER_52_604 VGND VGND VPWR VPWR sky130_fd_sc_hd__decap_4
XFILLER_101_18 VPWR VGND VPWR VGND sky130_ef_sc_hd__decap_12
XFILLER_17_391 VGND VGND VPWR VPWR sky130_fd_sc_hd__fill_1
X_4953_ clknet_leaf_2_clk _1008_ _0139_ VGND VGND VPWR VPWR acc.byte0\[6\] sky130_fd_sc_hd__dfrtp_1
X_3904_ lsu.load_fifo.queue\[8\]\[13\] lsu.load_fifo.queue\[9\]\[13\] lsu.load_fifo.queue\[10\]\[13\]
+ lsu.load_fifo.queue\[11\]\[13\] net385 net368 VGND VGND VPWR VPWR _1358_ sky130_fd_sc_hd__mux4_1
X_4884_ clknet_leaf_85_clk _0939_ VGND VGND VPWR VPWR lsu.load_fifo.queue\[12\]\[11\]
+ sky130_fd_sc_hd__dfxtp_1
X_3835_ net1257 _1299_ net256 VGND VGND VPWR VPWR _1026_ sky130_fd_sc_hd__mux2_1
XFILLER_20_589 VPWR VGND VPWR VGND sky130_ef_sc_hd__decap_12
XTAP_TAPCELL_ROW_30_562 VGND VPWR sky130_fd_sc_hd__tapvpwrvgnd_1
X_3766_ _1219_ _1221_ VGND VGND VPWR VPWR _1241_ sky130_fd_sc_hd__xnor2_1
X_2717_ _2016_ _2024_ VGND VGND VPWR VPWR _2025_ sky130_fd_sc_hd__nor2_4
XFILLER_106_617 VGND VGND VPWR VPWR sky130_fd_sc_hd__decap_8
X_3697_ _1172_ _1177_ VGND VGND VPWR VPWR _1179_ sky130_fd_sc_hd__nand2_1
X_2648_ _1116_ lsu.loader_state\[0\] _1777_ _1666_ VGND VGND VPWR VPWR _0415_ sky130_fd_sc_hd__a31o_1
X_2579_ lsu.current_load_addr\[8\] _1971_ net162 VGND VGND VPWR VPWR _0735_ sky130_fd_sc_hd__mux2_4
X_4318_ clknet_leaf_30_clk _0375_ VGND VGND VPWR VPWR lsu.load_fifo.queue\[10\]\[24\]
+ sky130_fd_sc_hd__dfxtp_1
XPHY_EDGE_ROW_98_Left_205 VGND VGND VPWR VPWR sky130_fd_sc_hd__decap_3
X_4249_ clknet_leaf_67_clk _0306_ VGND VGND VPWR VPWR lsu.store_fifo.queue\[2\]\[7\]
+ sky130_fd_sc_hd__dfxtp_1
XFILLER_101_399 VPWR VGND VPWR VGND sky130_ef_sc_hd__decap_12
XFILLER_28_601 VGND VGND VPWR VPWR sky130_fd_sc_hd__fill_1
XTAP_TAPCELL_ROW_2_254 VGND VPWR sky130_fd_sc_hd__tapvpwrvgnd_1
XFILLER_82_261 VPWR VGND VPWR VGND sky130_ef_sc_hd__decap_12
XTAP_TAPCELL_ROW_66_960 VGND VPWR sky130_fd_sc_hd__tapvpwrvgnd_1
XTAP_TAPCELL_ROW_38_651 VGND VPWR sky130_fd_sc_hd__tapvpwrvgnd_1
XFILLER_43_615 VGND VGND VPWR VPWR sky130_fd_sc_hd__fill_1
XFILLER_70_445 VPWR VGND VPWR VGND sky130_ef_sc_hd__decap_12
XFILLER_42_125 VGND VGND VPWR VPWR sky130_fd_sc_hd__decap_3
XFILLER_30_309 VGND VGND VPWR VPWR sky130_fd_sc_hd__fill_1
XFILLER_70_489 VPWR VGND VPWR VGND sky130_ef_sc_hd__decap_12
XFILLER_7_505 VPWR VGND VPWR VGND sky130_ef_sc_hd__decap_12
XFILLER_51_77 VGND VGND VPWR VPWR sky130_fd_sc_hd__decap_4
XFILLER_51_99 VGND VGND VPWR VPWR sky130_fd_sc_hd__decap_4
XFILLER_76_41 VGND VGND VPWR VPWR sky130_fd_sc_hd__fill_2
XFILLER_78_589 VPWR VGND VPWR VGND sky130_ef_sc_hd__decap_12
XFILLER_46_475 VGND VGND VPWR VPWR sky130_fd_sc_hd__fill_1
XFILLER_41_180 VGND VGND VPWR VPWR sky130_fd_sc_hd__decap_3
X_3620_ lsu.load_counter\[8\] VGND VGND VPWR VPWR _1103_ sky130_fd_sc_hd__inv_2
X_3551_ net443 VGND VGND VPWR VPWR _0115_ sky130_fd_sc_hd__inv_2
X_2502_ _1713_ _1835_ _1831_ _1715_ VGND VGND VPWR VPWR _1913_ sky130_fd_sc_hd__a31o_1
X_3482_ net441 VGND VGND VPWR VPWR _0046_ sky130_fd_sc_hd__inv_2
XFILLER_88_309 VGND VGND VPWR VPWR sky130_fd_sc_hd__decap_6
X_2433_ net89 net268 net241 VGND VGND VPWR VPWR _1866_ sky130_fd_sc_hd__o21a_1
X_2364_ lsu.store_counter\[7\] _1619_ VGND VGND VPWR VPWR _1803_ sky130_fd_sc_hd__nand2_1
X_4103_ net400 _1532_ net403 VGND VGND VPWR VPWR _1535_ sky130_fd_sc_hd__o21ai_1
X_2295_ lsu.store_counter\[12\] net240 _1730_ lsu.store_counter\[13\] VGND VGND VPWR
+ VPWR _1751_ sky130_fd_sc_hd__a31o_1
X_4034_ lsu.store_fifo.queue\[4\]\[7\] lsu.store_fifo.queue\[5\]\[7\] lsu.store_fifo.queue\[6\]\[7\]
+ lsu.store_fifo.queue\[7\]\[7\] net413 net408 VGND VGND VPWR VPWR _1472_ sky130_fd_sc_hd__mux4_1
XFILLER_25_615 VGND VGND VPWR VPWR sky130_fd_sc_hd__fill_1
XTAP_TAPCELL_ROW_35_610 VGND VPWR sky130_fd_sc_hd__tapvpwrvgnd_1
X_4936_ clknet_leaf_75_clk _0991_ VGND VGND VPWR VPWR lsu.load_fifo.queue\[13\]\[31\]
+ sky130_fd_sc_hd__dfxtp_1
X_4867_ clknet_leaf_43_clk _0922_ _0117_ VGND VGND VPWR VPWR lsu.load_counter\[17\]
+ sky130_fd_sc_hd__dfrtp_1
X_3818_ lsu.load_fifo.queue\[12\]\[26\] lsu.load_fifo.queue\[13\]\[26\] lsu.load_fifo.queue\[14\]\[26\]
+ lsu.load_fifo.queue\[15\]\[26\] net392 net375 VGND VGND VPWR VPWR _1285_ sky130_fd_sc_hd__mux4_1
X_4798_ clknet_leaf_30_clk _0855_ VGND VGND VPWR VPWR lsu.load_fifo.data_in\[8\] sky130_fd_sc_hd__dfxtp_1
X_3749_ _1171_ _1230_ _1170_ VGND VGND VPWR VPWR _1231_ sky130_fd_sc_hd__o21ai_1
XTAP_TAPCELL_ROW_76_1066 VGND VPWR sky130_fd_sc_hd__tapvpwrvgnd_1
XTAP_TAPCELL_ROW_7_302 VGND VPWR sky130_fd_sc_hd__tapvpwrvgnd_1
Xoutput150 net150 VGND VGND VPWR VPWR store_data[1] sky130_fd_sc_hd__buf_2
XFILLER_87_331 VGND VGND VPWR VPWR sky130_fd_sc_hd__decap_4
XFILLER_47_217 VGND VGND VPWR VPWR sky130_fd_sc_hd__decap_6
XFILLER_28_475 VGND VGND VPWR VPWR sky130_fd_sc_hd__fill_1
XFILLER_43_401 VGND VGND VPWR VPWR sky130_fd_sc_hd__fill_1
XTAP_TAPCELL_ROW_87_1184 VGND VPWR sky130_fd_sc_hd__tapvpwrvgnd_1
XFILLER_15_169 VGND VGND VPWR VPWR sky130_fd_sc_hd__decap_3
XFILLER_102_83 VGND VGND VPWR VPWR sky130_fd_sc_hd__fill_1
XFILLER_70_286 VGND VGND VPWR VPWR sky130_fd_sc_hd__fill_2
XFILLER_31_629 VGND VGND VPWR VPWR sky130_fd_sc_hd__fill_1
XFILLER_7_324 VGND VGND VPWR VPWR sky130_fd_sc_hd__decap_4
XTAP_TAPCELL_ROW_41_679 VGND VPWR sky130_fd_sc_hd__tapvpwrvgnd_1
XFILLER_3_541 VPWR VGND VPWR VGND sky130_ef_sc_hd__decap_12
XFILLER_87_51 VGND VGND VPWR VPWR sky130_fd_sc_hd__decap_4
XFILLER_3_585 VPWR VGND VPWR VGND sky130_ef_sc_hd__decap_12
X_2080_ net15 _1567_ VGND VGND VPWR VPWR _1570_ sky130_fd_sc_hd__or2_1
XTAP_TAPCELL_ROW_49_768 VGND VPWR sky130_fd_sc_hd__tapvpwrvgnd_1
X_2982_ net654 net336 net189 VGND VGND VPWR VPWR _0490_ sky130_fd_sc_hd__mux2_1
XFILLER_22_629 VGND VGND VPWR VPWR sky130_fd_sc_hd__fill_1
X_4721_ clknet_leaf_25_clk _0778_ VGND VGND VPWR VPWR net107 sky130_fd_sc_hd__dfxtp_1
XFILLER_61_297 VGND VGND VPWR VPWR sky130_fd_sc_hd__fill_1
X_4652_ clknet_leaf_36_clk _0709_ _0008_ VGND VGND VPWR VPWR lsu.load_fifo.w_ptr\[0\]
+ sky130_fd_sc_hd__dfrtp_4
Xinput30 load_base_addr[15] VGND VGND VPWR VPWR net30 sky130_fd_sc_hd__clkbuf_1
X_3603_ net430 VGND VGND VPWR VPWR _0167_ sky130_fd_sc_hd__inv_2
Xinput63 load_data[24] VGND VGND VPWR VPWR net63 sky130_fd_sc_hd__clkbuf_1
Xinput41 load_base_addr[5] VGND VGND VPWR VPWR net41 sky130_fd_sc_hd__clkbuf_1
X_4583_ clknet_leaf_76_clk _0640_ VGND VGND VPWR VPWR lsu.load_fifo.queue\[0\]\[31\]
+ sky130_fd_sc_hd__dfxtp_1
Xinput52 load_data[14] VGND VGND VPWR VPWR net52 sky130_fd_sc_hd__clkbuf_1
Xhold803 acc.byte3\[1\] VGND VGND VPWR VPWR net1271 sky130_fd_sc_hd__dlygate4sd3_1
Xhold814 lsu.current_store_addr\[17\] VGND VGND VPWR VPWR net1282 sky130_fd_sc_hd__dlygate4sd3_1
X_3534_ net435 VGND VGND VPWR VPWR _0098_ sky130_fd_sc_hd__inv_2
Xhold825 lsu.store_fifo.w_ptr\[2\] VGND VGND VPWR VPWR net1293 sky130_fd_sc_hd__dlygate4sd3_1
Xinput85 store_base_addr[14] VGND VGND VPWR VPWR net85 sky130_fd_sc_hd__clkbuf_1
Xinput74 load_data[5] VGND VGND VPWR VPWR net74 sky130_fd_sc_hd__clkbuf_1
Xinput96 store_base_addr[4] VGND VGND VPWR VPWR net96 sky130_fd_sc_hd__clkbuf_1
Xhold836 acc.byte3\[6\] VGND VGND VPWR VPWR net1304 sky130_fd_sc_hd__dlygate4sd3_1
X_3465_ net426 VGND VGND VPWR VPWR _0029_ sky130_fd_sc_hd__inv_2
XFILLER_88_139 VGND VGND VPWR VPWR sky130_fd_sc_hd__fill_1
X_2416_ lsu.current_store_addr\[14\] lsu.current_store_addr\[13\] _1851_ VGND VGND
+ VPWR VPWR _1852_ sky130_fd_sc_hd__and3_1
X_3396_ net884 net330 net200 VGND VGND VPWR VPWR _1046_ sky130_fd_sc_hd__mux2_1
X_2347_ lsu.store_counter\[16\] _1576_ _1578_ lsu.store_counter\[17\] VGND VGND VPWR
+ VPWR _1786_ sky130_fd_sc_hd__o22ai_1
X_2278_ _1721_ _1734_ VGND VGND VPWR VPWR _1741_ sky130_fd_sc_hd__nor2_1
XFILLER_57_559 VGND VGND VPWR VPWR sky130_fd_sc_hd__fill_1
X_4017_ net247 _1456_ VGND VGND VPWR VPWR _1457_ sky130_fd_sc_hd__nand2_1
XFILLER_37_250 VGND VGND VPWR VPWR sky130_fd_sc_hd__decap_8
XFILLER_25_401 VGND VGND VPWR VPWR sky130_fd_sc_hd__decap_3
XFILLER_25_412 VGND VGND VPWR VPWR sky130_fd_sc_hd__fill_2
XFILLER_65_570 VGND VGND VPWR VPWR sky130_fd_sc_hd__fill_2
XFILLER_52_253 VGND VGND VPWR VPWR sky130_fd_sc_hd__fill_1
XFILLER_13_629 VGND VGND VPWR VPWR sky130_fd_sc_hd__fill_1
X_4919_ clknet_leaf_3_clk _0974_ VGND VGND VPWR VPWR lsu.load_fifo.queue\[13\]\[14\]
+ sky130_fd_sc_hd__dfxtp_1
XFILLER_32_79 VGND VGND VPWR VPWR sky130_fd_sc_hd__decap_4
XFILLER_106_244 VGND VGND VPWR VPWR sky130_fd_sc_hd__decap_4
XFILLER_0_533 VGND VGND VPWR VPWR sky130_fd_sc_hd__fill_2
XFILLER_94_109 VPWR VGND VPWR VGND sky130_ef_sc_hd__decap_12
XTAP_TAPCELL_ROW_89_1213 VGND VPWR sky130_fd_sc_hd__tapvpwrvgnd_1
XFILLER_75_345 VGND VGND VPWR VPWR sky130_fd_sc_hd__decap_4
XTAP_TAPCELL_ROW_18_429 VGND VPWR sky130_fd_sc_hd__tapvpwrvgnd_1
XTAP_TAPCELL_ROW_46_738 VGND VPWR sky130_fd_sc_hd__tapvpwrvgnd_1
XFILLER_71_551 VGND VGND VPWR VPWR sky130_fd_sc_hd__decap_8
XFILLER_16_445 VPWR VGND VPWR VGND sky130_ef_sc_hd__decap_12
XFILLER_16_489 VPWR VGND VPWR VGND sky130_ef_sc_hd__decap_12
XFILLER_43_286 VGND VGND VPWR VPWR sky130_fd_sc_hd__fill_2
XFILLER_7_143 VPWR VGND VPWR VGND sky130_ef_sc_hd__decap_12
XFILLER_98_83 VGND VGND VPWR VPWR sky130_fd_sc_hd__fill_1
X_3250_ net444 _1838_ VGND VGND VPWR VPWR _2052_ sky130_fd_sc_hd__or2_2
XFILLER_3_393 VPWR VGND VPWR VGND sky130_ef_sc_hd__decap_12
X_2201_ net167 net164 _1674_ net244 lsu.load_counter\[16\] VGND VGND VPWR VPWR _1686_
+ sky130_fd_sc_hd__o2111a_1
X_3181_ net762 net336 net203 VGND VGND VPWR VPWR _0682_ sky130_fd_sc_hd__mux2_1
X_2132_ net18 net421 VGND VGND VPWR VPWR _1622_ sky130_fd_sc_hd__xnor2_2
XFILLER_14_3 VGND VGND VPWR VPWR sky130_fd_sc_hd__decap_8
X_2063_ net17 net16 net2 net13 VGND VGND VPWR VPWR _1553_ sky130_fd_sc_hd__nor4_1
X_2965_ net300 net994 net215 VGND VGND VPWR VPWR _0476_ sky130_fd_sc_hd__mux2_1
X_4704_ clknet_leaf_50_clk _0761_ VGND VGND VPWR VPWR lsu.store_fifo.queue\[14\]\[8\]
+ sky130_fd_sc_hd__dfxtp_1
X_2896_ net1073 net306 net196 VGND VGND VPWR VPWR _0407_ sky130_fd_sc_hd__mux2_1
X_4635_ clknet_leaf_8_clk _0692_ VGND VGND VPWR VPWR lsu.load_fifo.queue\[15\]\[19\]
+ sky130_fd_sc_hd__dfxtp_1
XPHY_EDGE_ROW_62_Left_169 VGND VGND VPWR VPWR sky130_fd_sc_hd__decap_3
X_4566_ clknet_leaf_1_clk _0623_ VGND VGND VPWR VPWR lsu.load_fifo.queue\[0\]\[14\]
+ sky130_fd_sc_hd__dfxtp_1
Xhold611 lsu.store_fifo.queue\[9\]\[5\] VGND VGND VPWR VPWR net1079 sky130_fd_sc_hd__dlygate4sd3_1
Xhold600 lsu.load_fifo.queue\[3\]\[5\] VGND VGND VPWR VPWR net1068 sky130_fd_sc_hd__dlygate4sd3_1
X_3517_ net436 VGND VGND VPWR VPWR _0081_ sky130_fd_sc_hd__inv_2
Xhold622 lsu.load_fifo.queue\[3\]\[17\] VGND VGND VPWR VPWR net1090 sky130_fd_sc_hd__dlygate4sd3_1
Xhold633 lsu.store_fifo.queue\[11\]\[9\] VGND VGND VPWR VPWR net1101 sky130_fd_sc_hd__dlygate4sd3_1
Xhold644 lsu.store_fifo.queue\[7\]\[3\] VGND VGND VPWR VPWR net1112 sky130_fd_sc_hd__dlygate4sd3_1
Xhold655 _0823_ VGND VGND VPWR VPWR net1123 sky130_fd_sc_hd__dlygate4sd3_1
XTAP_TAPCELL_ROW_73_1036 VGND VPWR sky130_fd_sc_hd__tapvpwrvgnd_1
Xhold688 net148 VGND VGND VPWR VPWR net1156 sky130_fd_sc_hd__dlygate4sd3_1
X_4497_ clknet_leaf_82_clk _0554_ VGND VGND VPWR VPWR lsu.load_fifo.queue\[2\]\[9\]
+ sky130_fd_sc_hd__dfxtp_1
Xhold666 lsu.load_fifo.queue\[9\]\[27\] VGND VGND VPWR VPWR net1134 sky130_fd_sc_hd__dlygate4sd3_1
Xhold677 lsu.store_fifo.queue\[0\]\[7\] VGND VGND VPWR VPWR net1145 sky130_fd_sc_hd__dlygate4sd3_1
X_3448_ net431 VGND VGND VPWR VPWR _0012_ sky130_fd_sc_hd__inv_2
Xhold699 lsu.load_fifo.queue\[1\]\[26\] VGND VGND VPWR VPWR net1167 sky130_fd_sc_hd__dlygate4sd3_1
X_3379_ net299 net969 net171 VGND VGND VPWR VPWR _0988_ sky130_fd_sc_hd__mux2_1
XPHY_EDGE_ROW_71_Left_178 VGND VGND VPWR VPWR sky130_fd_sc_hd__decap_3
XFILLER_84_197 VGND VGND VPWR VPWR sky130_fd_sc_hd__fill_2
XFILLER_27_57 VGND VGND VPWR VPWR sky130_fd_sc_hd__fill_1
XFILLER_25_231 VGND VGND VPWR VPWR sky130_fd_sc_hd__fill_1
XTAP_TAPCELL_ROW_43_708 VGND VPWR sky130_fd_sc_hd__tapvpwrvgnd_1
XTAP_TAPCELL_ROW_84_1154 VGND VPWR sky130_fd_sc_hd__tapvpwrvgnd_1
XFILLER_80_370 VGND VGND VPWR VPWR sky130_fd_sc_hd__fill_2
Xclone11 _1663_ VGND VGND VPWR VPWR net479 sky130_fd_sc_hd__clkbuf_1
XPHY_EDGE_ROW_80_Left_187 VGND VGND VPWR VPWR sky130_fd_sc_hd__decap_3
XTAP_TAPCELL_ROW_23_487 VGND VPWR sky130_fd_sc_hd__tapvpwrvgnd_1
XTAP_TAPCELL_ROW_51_796 VGND VPWR sky130_fd_sc_hd__tapvpwrvgnd_1
XTAP_TAPCELL_ROW_95_1272 VGND VPWR sky130_fd_sc_hd__tapvpwrvgnd_1
XFILLER_4_135 VGND VGND VPWR VPWR sky130_fd_sc_hd__decap_4
XFILLER_88_470 VGND VGND VPWR VPWR sky130_fd_sc_hd__decap_6
XTAP_TAPCELL_ROW_59_874 VGND VPWR sky130_fd_sc_hd__tapvpwrvgnd_1
XFILLER_63_304 VGND VGND VPWR VPWR sky130_fd_sc_hd__fill_2
XFILLER_29_570 VGND VGND VPWR VPWR sky130_fd_sc_hd__fill_1
XFILLER_63_337 VGND VGND VPWR VPWR sky130_fd_sc_hd__decap_4
XFILLER_16_253 VGND VGND VPWR VPWR sky130_fd_sc_hd__fill_2
XFILLER_44_595 VGND VGND VPWR VPWR sky130_fd_sc_hd__fill_2
X_2750_ net290 net575 _2027_ VGND VGND VPWR VPWR _0269_ sky130_fd_sc_hd__mux2_1
X_2681_ net910 net339 net233 VGND VGND VPWR VPWR _0205_ sky130_fd_sc_hd__mux2_1
X_4420_ clknet_leaf_15_clk _0477_ VGND VGND VPWR VPWR lsu.load_fifo.queue\[5\]\[28\]
+ sky130_fd_sc_hd__dfxtp_1
XFILLER_98_212 VGND VGND VPWR VPWR sky130_fd_sc_hd__decap_3
X_4351_ clknet_leaf_68_clk _0408_ VGND VGND VPWR VPWR lsu.load_fifo.queue\[7\]\[25\]
+ sky130_fd_sc_hd__dfxtp_1
XFILLER_98_245 VGND VGND VPWR VPWR sky130_fd_sc_hd__decap_6
X_4282_ clknet_leaf_85_clk _0339_ VGND VGND VPWR VPWR lsu.load_fifo.queue\[9\]\[20\]
+ sky130_fd_sc_hd__dfxtp_1
X_3302_ net1305 net55 net249 VGND VGND VPWR VPWR _0864_ sky130_fd_sc_hd__mux2_1
Xfanout409 lsu.store_fifo.r_ptr\[1\] VGND VGND VPWR VPWR net409 sky130_fd_sc_hd__clkbuf_4
X_3233_ net625 lsu.current_load_addr\[5\] net237 VGND VGND VPWR VPWR _0771_ sky130_fd_sc_hd__mux2_1
XFILLER_104_18 VGND VGND VPWR VPWR sky130_fd_sc_hd__decap_8
XFILLER_104_29 VPWR VGND VPWR VGND sky130_ef_sc_hd__decap_12
X_3164_ net821 net304 net178 VGND VGND VPWR VPWR _0666_ sky130_fd_sc_hd__mux2_1
X_2115_ _1123_ _1557_ _1122_ VGND VGND VPWR VPWR _1605_ sky130_fd_sc_hd__a21o_1
X_3095_ net310 net1155 net186 VGND VGND VPWR VPWR _0599_ sky130_fd_sc_hd__mux2_1
XFILLER_66_197 VGND VGND VPWR VPWR sky130_fd_sc_hd__decap_8
XFILLER_62_381 VGND VGND VPWR VPWR sky130_fd_sc_hd__decap_8
X_3997_ lsu.load_fifo.queue\[8\]\[0\] lsu.load_fifo.queue\[9\]\[0\] lsu.load_fifo.queue\[10\]\[0\]
+ lsu.load_fifo.queue\[11\]\[0\] net397 net380 VGND VGND VPWR VPWR _1438_ sky130_fd_sc_hd__mux4_1
XFILLER_13_15 VGND VGND VPWR VPWR sky130_fd_sc_hd__decap_4
X_2948_ net334 net987 net216 VGND VGND VPWR VPWR _0459_ sky130_fd_sc_hd__mux2_1
XTAP_TAPCELL_ROW_20_446 VGND VPWR sky130_fd_sc_hd__tapvpwrvgnd_1
X_4618_ clknet_leaf_20_clk _0675_ VGND VGND VPWR VPWR lsu.load_fifo.queue\[15\]\[2\]
+ sky130_fd_sc_hd__dfxtp_1
X_2879_ net744 net341 net196 VGND VGND VPWR VPWR _0390_ sky130_fd_sc_hd__mux2_1
X_4549_ clknet_leaf_15_clk _0606_ VGND VGND VPWR VPWR lsu.load_fifo.queue\[1\]\[29\]
+ sky130_fd_sc_hd__dfxtp_1
Xhold452 lsu.load_fifo.queue\[15\]\[23\] VGND VGND VPWR VPWR net920 sky130_fd_sc_hd__dlygate4sd3_1
Xhold441 lsu.load_fifo.queue\[5\]\[22\] VGND VGND VPWR VPWR net909 sky130_fd_sc_hd__dlygate4sd3_1
Xhold463 lsu.store_fifo.queue\[6\]\[5\] VGND VGND VPWR VPWR net931 sky130_fd_sc_hd__dlygate4sd3_1
Xhold430 _0826_ VGND VGND VPWR VPWR net898 sky130_fd_sc_hd__dlygate4sd3_1
Xhold485 net109 VGND VGND VPWR VPWR net953 sky130_fd_sc_hd__dlygate4sd3_1
XFILLER_89_223 VGND VGND VPWR VPWR sky130_fd_sc_hd__fill_1
Xhold474 lsu.load_fifo.queue\[4\]\[1\] VGND VGND VPWR VPWR net942 sky130_fd_sc_hd__dlygate4sd3_1
Xhold496 lsu.load_fifo.queue\[2\]\[19\] VGND VGND VPWR VPWR net964 sky130_fd_sc_hd__dlygate4sd3_1
XFILLER_104_589 VPWR VGND VPWR VGND sky130_ef_sc_hd__decap_12
XFILLER_49_109 VGND VGND VPWR VPWR sky130_fd_sc_hd__decap_3
XFILLER_85_495 VGND VGND VPWR VPWR sky130_fd_sc_hd__fill_1
XFILLER_72_101 VGND VGND VPWR VPWR sky130_fd_sc_hd__fill_2
XFILLER_18_529 VGND VGND VPWR VPWR sky130_fd_sc_hd__decap_3
XTAP_TAPCELL_ROW_28_535 VGND VPWR sky130_fd_sc_hd__tapvpwrvgnd_1
XFILLER_45_337 VGND VGND VPWR VPWR sky130_fd_sc_hd__decap_6
XTAP_TAPCELL_ROW_56_844 VGND VPWR sky130_fd_sc_hd__tapvpwrvgnd_1
XFILLER_26_562 VGND VGND VPWR VPWR sky130_fd_sc_hd__decap_3
XFILLER_13_223 VGND VGND VPWR VPWR sky130_fd_sc_hd__fill_1
XTAP_TAPCELL_ROW_97_1301 VGND VPWR sky130_fd_sc_hd__tapvpwrvgnd_1
XFILLER_70_65 VGND VGND VPWR VPWR sky130_fd_sc_hd__fill_1
Xclkload19 clknet_leaf_9_clk VGND VGND VPWR VPWR clkload19/Y sky130_fd_sc_hd__inv_6
XFILLER_95_237 VPWR VGND VPWR VGND sky130_ef_sc_hd__decap_12
XFILLER_95_51 VGND VGND VPWR VPWR sky130_fd_sc_hd__decap_4
XFILLER_36_315 VGND VGND VPWR VPWR sky130_fd_sc_hd__fill_1
XFILLER_48_197 VGND VGND VPWR VPWR sky130_fd_sc_hd__fill_1
X_3920_ _1370_ _1371_ net360 VGND VGND VPWR VPWR _1372_ sky130_fd_sc_hd__mux2_1
XFILLER_17_573 VPWR VGND VPWR VGND sky130_ef_sc_hd__decap_12
XFILLER_44_381 VPWR VGND VPWR VGND sky130_ef_sc_hd__decap_12
XTAP_TAPCELL_ROW_102_1349 VGND VPWR sky130_fd_sc_hd__tapvpwrvgnd_1
X_3851_ net1266 _1313_ net255 VGND VGND VPWR VPWR _1024_ sky130_fd_sc_hd__mux2_1
XFILLER_81_3 VPWR VGND VPWR VGND sky130_ef_sc_hd__decap_12
X_3782_ _1253_ VGND VGND VPWR VPWR _1254_ sky130_fd_sc_hd__inv_2
X_2802_ net276 net1087 _2032_ VGND VGND VPWR VPWR _0316_ sky130_fd_sc_hd__mux2_1
X_2733_ net281 net978 net234 VGND VGND VPWR VPWR _0254_ sky130_fd_sc_hd__mux2_1
X_2664_ net527 net287 _2021_ VGND VGND VPWR VPWR _0189_ sky130_fd_sc_hd__mux2_1
X_2595_ lsu.current_load_addr\[3\] _1920_ VGND VGND VPWR VPWR _1983_ sky130_fd_sc_hd__nor2_1
X_4403_ clknet_leaf_86_clk _0460_ VGND VGND VPWR VPWR lsu.load_fifo.queue\[5\]\[11\]
+ sky130_fd_sc_hd__dfxtp_1
X_4334_ clknet_leaf_11_clk _0391_ VGND VGND VPWR VPWR lsu.load_fifo.queue\[7\]\[8\]
+ sky130_fd_sc_hd__dfxtp_1
Xfanout228 _2033_ VGND VGND VPWR VPWR net228 sky130_fd_sc_hd__buf_4
Xfanout217 _2037_ VGND VGND VPWR VPWR net217 sky130_fd_sc_hd__buf_2
XFILLER_5_93 VGND VGND VPWR VPWR sky130_fd_sc_hd__fill_2
Xfanout206 _2043_ VGND VGND VPWR VPWR net206 sky130_fd_sc_hd__buf_4
Xfanout239 net240 VGND VGND VPWR VPWR net239 sky130_fd_sc_hd__buf_2
X_4265_ clknet_leaf_87_clk _0322_ VGND VGND VPWR VPWR lsu.load_fifo.queue\[9\]\[3\]
+ sky130_fd_sc_hd__dfxtp_1
X_4196_ clknet_leaf_56_clk _0253_ VGND VGND VPWR VPWR lsu.store_fifo.queue\[7\]\[4\]
+ sky130_fd_sc_hd__dfxtp_1
X_3216_ _2020_ _2048_ VGND VGND VPWR VPWR _2050_ sky130_fd_sc_hd__nor2_4
XFILLER_27_304 VGND VGND VPWR VPWR sky130_fd_sc_hd__fill_2
XFILLER_27_326 VGND VGND VPWR VPWR sky130_fd_sc_hd__fill_2
X_3147_ net680 net339 net179 VGND VGND VPWR VPWR _0649_ sky130_fd_sc_hd__mux2_1
XFILLER_82_421 VPWR VGND VPWR VGND sky130_ef_sc_hd__decap_12
XFILLER_27_337 VGND VGND VPWR VPWR sky130_fd_sc_hd__decap_6
XFILLER_54_112 VGND VGND VPWR VPWR sky130_fd_sc_hd__fill_1
XTAP_TAPCELL_ROW_25_505 VGND VPWR sky130_fd_sc_hd__tapvpwrvgnd_1
X_3078_ net345 net1159 net187 VGND VGND VPWR VPWR _0582_ sky130_fd_sc_hd__mux2_1
XTAP_TAPCELL_ROW_53_814 VGND VPWR sky130_fd_sc_hd__tapvpwrvgnd_1
XTAP_TAPCELL_ROW_81_1124 VGND VPWR sky130_fd_sc_hd__tapvpwrvgnd_1
XTAP_TAPCELL_ROW_33_593 VGND VPWR sky130_fd_sc_hd__tapvpwrvgnd_1
XTAP_TAPCELL_ROW_79_1097 VGND VPWR sky130_fd_sc_hd__tapvpwrvgnd_1
XTAP_TAPCELL_ROW_92_1242 VGND VPWR sky130_fd_sc_hd__tapvpwrvgnd_1
Xhold271 lsu.load_fifo.queue\[6\]\[31\] VGND VGND VPWR VPWR net739 sky130_fd_sc_hd__dlygate4sd3_1
Xhold260 lsu.load_fifo.queue\[0\]\[13\] VGND VGND VPWR VPWR net728 sky130_fd_sc_hd__dlygate4sd3_1
Xhold282 lsu.load_fifo.queue\[10\]\[2\] VGND VGND VPWR VPWR net750 sky130_fd_sc_hd__dlygate4sd3_1
XFILLER_2_469 VGND VGND VPWR VPWR sky130_fd_sc_hd__decap_6
Xhold293 lsu.store_fifo.queue\[2\]\[7\] VGND VGND VPWR VPWR net761 sky130_fd_sc_hd__dlygate4sd3_1
XFILLER_104_397 VGND VGND VPWR VPWR sky130_fd_sc_hd__fill_2
XTAP_TAPCELL_ROW_69_991 VGND VPWR sky130_fd_sc_hd__tapvpwrvgnd_1
XTAP_TAPCELL_ROW_5_285 VGND VPWR sky130_fd_sc_hd__tapvpwrvgnd_1
XFILLER_58_473 VGND VGND VPWR VPWR sky130_fd_sc_hd__decap_3
XFILLER_65_54 VGND VGND VPWR VPWR sky130_fd_sc_hd__fill_2
XFILLER_60_137 VGND VGND VPWR VPWR sky130_fd_sc_hd__decap_3
XFILLER_41_340 VGND VGND VPWR VPWR sky130_fd_sc_hd__fill_1
XFILLER_14_587 VGND VGND VPWR VPWR sky130_fd_sc_hd__fill_1
X_2380_ _1796_ _1801_ _1818_ VGND VGND VPWR VPWR _1819_ sky130_fd_sc_hd__and3_1
X_4050_ net247 _1486_ VGND VGND VPWR VPWR _1487_ sky130_fd_sc_hd__nand2_1
Xinput6 count[13] VGND VGND VPWR VPWR net6 sky130_fd_sc_hd__buf_1
X_3001_ net998 net298 net191 VGND VGND VPWR VPWR _0509_ sky130_fd_sc_hd__mux2_1
XFILLER_76_281 VGND VGND VPWR VPWR sky130_fd_sc_hd__fill_2
XFILLER_91_273 VGND VGND VPWR VPWR sky130_fd_sc_hd__decap_6
X_4952_ clknet_leaf_7_clk _1007_ _0138_ VGND VGND VPWR VPWR acc.byte0\[5\] sky130_fd_sc_hd__dfrtp_1
X_4883_ clknet_leaf_24_clk _0938_ VGND VGND VPWR VPWR lsu.load_fifo.queue\[12\]\[10\]
+ sky130_fd_sc_hd__dfxtp_1
X_3903_ net1269 _1357_ net253 VGND VGND VPWR VPWR _1016_ sky130_fd_sc_hd__mux2_1
X_3834_ _1296_ _1298_ _1295_ _1297_ net359 net363 VGND VGND VPWR VPWR _1299_ sky130_fd_sc_hd__mux4_1
XFILLER_32_362 VGND VGND VPWR VPWR sky130_fd_sc_hd__fill_2
XFILLER_32_395 VGND VGND VPWR VPWR sky130_fd_sc_hd__fill_2
XTAP_TAPCELL_ROW_30_563 VGND VPWR sky130_fd_sc_hd__tapvpwrvgnd_1
X_3765_ net284 _1240_ _1125_ VGND VGND VPWR VPWR _1079_ sky130_fd_sc_hd__mux2_1
XFILLER_106_607 VGND VGND VPWR VPWR sky130_fd_sc_hd__decap_8
X_3696_ _1172_ _1177_ VGND VGND VPWR VPWR _1178_ sky130_fd_sc_hd__nor2_1
X_2716_ net420 lsu.store_fifo.w_ptr\[0\] _2011_ VGND VGND VPWR VPWR _2024_ sky130_fd_sc_hd__or3b_4
X_2647_ net46 net262 _1778_ VGND VGND VPWR VPWR _0416_ sky130_fd_sc_hd__o21ai_1
X_2578_ net44 _1970_ net264 VGND VGND VPWR VPWR _1971_ sky130_fd_sc_hd__mux2_1
X_4317_ clknet_leaf_80_clk _0374_ VGND VGND VPWR VPWR lsu.load_fifo.queue\[10\]\[23\]
+ sky130_fd_sc_hd__dfxtp_1
X_4248_ clknet_leaf_53_clk _0305_ VGND VGND VPWR VPWR lsu.store_fifo.queue\[2\]\[6\]
+ sky130_fd_sc_hd__dfxtp_1
XTAP_TAPCELL_ROW_2_255 VGND VPWR sky130_fd_sc_hd__tapvpwrvgnd_1
X_4179_ clknet_leaf_66_clk _0236_ VGND VGND VPWR VPWR lsu.store_fifo.queue\[9\]\[7\]
+ sky130_fd_sc_hd__dfxtp_1
XFILLER_27_134 VPWR VGND VPWR VGND sky130_ef_sc_hd__decap_12
XTAP_TAPCELL_ROW_66_961 VGND VPWR sky130_fd_sc_hd__tapvpwrvgnd_1
XTAP_TAPCELL_ROW_38_652 VGND VPWR sky130_fd_sc_hd__tapvpwrvgnd_1
XFILLER_82_273 VGND VGND VPWR VPWR sky130_fd_sc_hd__fill_1
XFILLER_70_457 VPWR VGND VPWR VGND sky130_ef_sc_hd__decap_12
Xclkbuf_3_3__f_clk clknet_0_clk VGND VGND VPWR VPWR clknet_3_3__leaf_clk sky130_fd_sc_hd__clkbuf_16
XPHY_EDGE_ROW_14_Right_14 VGND VGND VPWR VPWR sky130_fd_sc_hd__decap_3
XFILLER_7_517 VPWR VGND VPWR VGND sky130_ef_sc_hd__decap_12
XFILLER_78_546 VGND VGND VPWR VPWR sky130_fd_sc_hd__fill_1
XPHY_EDGE_ROW_23_Right_23 VGND VGND VPWR VPWR sky130_fd_sc_hd__decap_3
XFILLER_19_613 VGND VGND VPWR VPWR sky130_fd_sc_hd__decap_3
XFILLER_65_207 VGND VGND VPWR VPWR sky130_fd_sc_hd__fill_1
XFILLER_92_41 VPWR VGND VPWR VGND sky130_ef_sc_hd__decap_12
XFILLER_92_85 VPWR VGND VPWR VGND sky130_ef_sc_hd__decap_12
XPHY_EDGE_ROW_32_Right_32 VGND VGND VPWR VPWR sky130_fd_sc_hd__decap_3
X_3550_ net443 VGND VGND VPWR VPWR _0114_ sky130_fd_sc_hd__inv_2
X_2501_ _1910_ _1911_ VGND VGND VPWR VPWR _0764_ sky130_fd_sc_hd__nor2_1
X_3481_ net440 VGND VGND VPWR VPWR _0045_ sky130_fd_sc_hd__inv_2
X_2432_ _1855_ _1864_ _1718_ VGND VGND VPWR VPWR _1865_ sky130_fd_sc_hd__o21ai_1
XFILLER_69_502 VGND VGND VPWR VPWR sky130_fd_sc_hd__fill_2
XPHY_EDGE_ROW_41_Right_41 VGND VGND VPWR VPWR sky130_fd_sc_hd__decap_3
XFILLER_44_3 VGND VGND VPWR VPWR sky130_fd_sc_hd__decap_4
XFILLER_96_321 VPWR VGND VPWR VGND sky130_ef_sc_hd__decap_12
X_2363_ lsu.store_counter\[7\] _1619_ _1620_ lsu.store_counter\[6\] VGND VGND VPWR
+ VPWR _1802_ sky130_fd_sc_hd__o22ai_1
X_4102_ net270 _1533_ VGND VGND VPWR VPWR _1534_ sky130_fd_sc_hd__nor2_1
X_2294_ _1750_ _1749_ lsu.store_counter\[14\] VGND VGND VPWR VPWR _0894_ sky130_fd_sc_hd__mux2_1
X_4033_ net270 _1470_ VGND VGND VPWR VPWR _1471_ sky130_fd_sc_hd__nor2_1
XFILLER_2_83 VGND VGND VPWR VPWR sky130_fd_sc_hd__fill_1
XFILLER_37_443 VGND VGND VPWR VPWR sky130_fd_sc_hd__decap_4
XFILLER_49_281 VGND VGND VPWR VPWR sky130_fd_sc_hd__fill_1
XTAP_TAPCELL_ROW_35_611 VGND VPWR sky130_fd_sc_hd__tapvpwrvgnd_1
XFILLER_37_487 VGND VGND VPWR VPWR sky130_fd_sc_hd__fill_1
XPHY_EDGE_ROW_50_Right_50 VGND VGND VPWR VPWR sky130_fd_sc_hd__decap_3
XTAP_TAPCELL_ROW_63_920 VGND VPWR sky130_fd_sc_hd__tapvpwrvgnd_1
X_4935_ clknet_leaf_13_clk _0990_ VGND VGND VPWR VPWR lsu.load_fifo.queue\[13\]\[30\]
+ sky130_fd_sc_hd__dfxtp_1
X_4866_ clknet_leaf_42_clk _0921_ _0116_ VGND VGND VPWR VPWR lsu.load_counter\[16\]
+ sky130_fd_sc_hd__dfrtp_1
X_4797_ clknet_leaf_27_clk _0854_ VGND VGND VPWR VPWR lsu.load_fifo.data_in\[7\] sky130_fd_sc_hd__dfxtp_1
XTAP_TAPCELL_ROW_15_390 VGND VPWR sky130_fd_sc_hd__tapvpwrvgnd_1
XFILLER_20_365 VGND VGND VPWR VPWR sky130_fd_sc_hd__decap_3
X_3817_ lsu.load_fifo.queue\[0\]\[26\] lsu.load_fifo.queue\[1\]\[26\] lsu.load_fifo.queue\[2\]\[26\]
+ lsu.load_fifo.queue\[3\]\[26\] net392 net375 VGND VGND VPWR VPWR _1284_ sky130_fd_sc_hd__mux4_1
X_3748_ _1179_ _1228_ _1178_ VGND VGND VPWR VPWR _1230_ sky130_fd_sc_hd__a21oi_1
X_3679_ _1155_ _1160_ VGND VGND VPWR VPWR _1161_ sky130_fd_sc_hd__or2_1
Xoutput140 net140 VGND VGND VPWR VPWR store_addr[21] sky130_fd_sc_hd__buf_2
XTAP_TAPCELL_ROW_76_1067 VGND VPWR sky130_fd_sc_hd__tapvpwrvgnd_1
XTAP_TAPCELL_ROW_7_303 VGND VPWR sky130_fd_sc_hd__tapvpwrvgnd_1
Xoutput151 net151 VGND VGND VPWR VPWR store_data[2] sky130_fd_sc_hd__buf_2
XFILLER_102_621 VGND VGND VPWR VPWR sky130_fd_sc_hd__fill_1
XFILLER_75_505 VPWR VGND VPWR VGND sky130_ef_sc_hd__decap_12
XFILLER_90_519 VGND VGND VPWR VPWR sky130_fd_sc_hd__fill_1
XTAP_TAPCELL_ROW_87_1185 VGND VPWR sky130_fd_sc_hd__tapvpwrvgnd_1
XFILLER_43_435 VGND VGND VPWR VPWR sky130_fd_sc_hd__decap_4
XFILLER_70_276 VGND VGND VPWR VPWR sky130_fd_sc_hd__fill_1
Xclkbuf_leaf_50_clk clknet_3_7__leaf_clk VGND VGND VPWR VPWR clknet_leaf_50_clk sky130_fd_sc_hd__clkbuf_8
XFILLER_3_553 VGND VGND VPWR VPWR sky130_fd_sc_hd__decap_6
XFILLER_3_597 VPWR VGND VPWR VGND sky130_ef_sc_hd__decap_12
XFILLER_87_85 VPWR VGND VPWR VGND sky130_ef_sc_hd__decap_12
XFILLER_66_527 VGND VGND VPWR VPWR sky130_fd_sc_hd__decap_4
XFILLER_93_335 VGND VGND VPWR VPWR sky130_fd_sc_hd__fill_1
XFILLER_59_590 VGND VGND VPWR VPWR sky130_fd_sc_hd__decap_3
XFILLER_46_251 VGND VGND VPWR VPWR sky130_fd_sc_hd__fill_1
XTAP_TAPCELL_ROW_49_769 VGND VPWR sky130_fd_sc_hd__tapvpwrvgnd_1
XFILLER_19_476 VGND VGND VPWR VPWR sky130_fd_sc_hd__fill_1
XFILLER_61_232 VGND VGND VPWR VPWR sky130_fd_sc_hd__fill_1
X_2981_ net811 net338 net192 VGND VGND VPWR VPWR _0489_ sky130_fd_sc_hd__mux2_1
X_4720_ clknet_leaf_25_clk net534 VGND VGND VPWR VPWR net106 sky130_fd_sc_hd__dfxtp_1
Xclkbuf_leaf_41_clk clknet_3_7__leaf_clk VGND VGND VPWR VPWR clknet_leaf_41_clk sky130_fd_sc_hd__clkbuf_8
X_4651_ clknet_leaf_52_clk _0708_ _0007_ VGND VGND VPWR VPWR lsu.store_fifo.w_ptr\[3\]
+ sky130_fd_sc_hd__dfrtp_2
Xinput20 count[6] VGND VGND VPWR VPWR net20 sky130_fd_sc_hd__buf_1
Xinput31 load_base_addr[16] VGND VGND VPWR VPWR net31 sky130_fd_sc_hd__clkbuf_1
XTAP_TAPCELL_ROW_12_360 VGND VPWR sky130_fd_sc_hd__tapvpwrvgnd_1
X_3602_ net430 VGND VGND VPWR VPWR _0166_ sky130_fd_sc_hd__inv_2
Xinput42 load_base_addr[6] VGND VGND VPWR VPWR net42 sky130_fd_sc_hd__clkbuf_1
Xinput64 load_data[25] VGND VGND VPWR VPWR net64 sky130_fd_sc_hd__clkbuf_1
Xinput53 load_data[15] VGND VGND VPWR VPWR net53 sky130_fd_sc_hd__buf_1
X_4582_ clknet_leaf_11_clk _0639_ VGND VGND VPWR VPWR lsu.load_fifo.queue\[0\]\[30\]
+ sky130_fd_sc_hd__dfxtp_1
X_3533_ net435 VGND VGND VPWR VPWR _0097_ sky130_fd_sc_hd__inv_2
Xinput86 store_base_addr[15] VGND VGND VPWR VPWR net86 sky130_fd_sc_hd__clkbuf_1
Xhold826 acc.done VGND VGND VPWR VPWR net1294 sky130_fd_sc_hd__dlygate4sd3_1
Xhold837 lsu.load_fifo.data_in\[17\] VGND VGND VPWR VPWR net1305 sky130_fd_sc_hd__dlygate4sd3_1
Xinput75 load_data[6] VGND VGND VPWR VPWR net75 sky130_fd_sc_hd__clkbuf_1
Xhold804 acc.byte3\[7\] VGND VGND VPWR VPWR net1272 sky130_fd_sc_hd__dlygate4sd3_1
Xinput97 store_base_addr[5] VGND VGND VPWR VPWR net97 sky130_fd_sc_hd__clkbuf_1
Xhold815 acc.byte2\[0\] VGND VGND VPWR VPWR net1283 sky130_fd_sc_hd__dlygate4sd3_1
X_3464_ net426 VGND VGND VPWR VPWR _0028_ sky130_fd_sc_hd__inv_2
XFILLER_88_129 VGND VGND VPWR VPWR sky130_fd_sc_hd__fill_1
X_2415_ lsu.current_store_addr\[12\] _1849_ VGND VGND VPWR VPWR _1851_ sky130_fd_sc_hd__and2_1
X_3395_ net1098 net333 net198 VGND VGND VPWR VPWR _1045_ sky130_fd_sc_hd__mux2_1
X_2346_ lsu.store_counter\[19\] _1583_ VGND VGND VPWR VPWR _1785_ sky130_fd_sc_hd__nor2_1
XFILLER_69_387 VGND VGND VPWR VPWR sky130_fd_sc_hd__fill_2
XFILLER_96_195 VGND VGND VPWR VPWR sky130_fd_sc_hd__fill_1
XFILLER_84_335 VPWR VGND VPWR VGND sky130_ef_sc_hd__decap_12
X_2277_ net268 _1734_ _1724_ VGND VGND VPWR VPWR _1740_ sky130_fd_sc_hd__a21o_1
X_4016_ net403 _1449_ _1451_ _1454_ _1455_ VGND VGND VPWR VPWR _1456_ sky130_fd_sc_hd__o32a_1
XFILLER_80_530 VGND VGND VPWR VPWR sky130_fd_sc_hd__fill_2
XFILLER_25_446 VGND VGND VPWR VPWR sky130_fd_sc_hd__fill_2
XFILLER_80_585 VGND VGND VPWR VPWR sky130_fd_sc_hd__decap_3
Xclkbuf_leaf_32_clk clknet_3_3__leaf_clk VGND VGND VPWR VPWR clknet_leaf_32_clk sky130_fd_sc_hd__clkbuf_8
X_4918_ clknet_leaf_4_clk _0973_ VGND VGND VPWR VPWR lsu.load_fifo.queue\[13\]\[13\]
+ sky130_fd_sc_hd__dfxtp_1
X_4849_ clknet_leaf_35_clk _0000_ _0099_ VGND VGND VPWR VPWR lsu.load_fifo.r_en sky130_fd_sc_hd__dfrtp_1
XFILLER_106_223 VGND VGND VPWR VPWR sky130_fd_sc_hd__fill_1
XFILLER_106_212 VGND VGND VPWR VPWR sky130_fd_sc_hd__fill_1
XFILLER_0_501 VGND VGND VPWR VPWR sky130_fd_sc_hd__decap_3
XFILLER_0_545 VGND VGND VPWR VPWR sky130_fd_sc_hd__decap_4
XFILLER_0_589 VGND VGND VPWR VPWR sky130_fd_sc_hd__fill_2
XFILLER_102_495 VGND VGND VPWR VPWR sky130_fd_sc_hd__fill_1
XTAP_TAPCELL_ROW_89_1214 VGND VPWR sky130_fd_sc_hd__tapvpwrvgnd_1
XFILLER_87_195 VGND VGND VPWR VPWR sky130_fd_sc_hd__fill_1
XFILLER_57_66 VGND VGND VPWR VPWR sky130_fd_sc_hd__fill_1
XTAP_TAPCELL_ROW_46_739 VGND VPWR sky130_fd_sc_hd__tapvpwrvgnd_1
XFILLER_16_457 VPWR VGND VPWR VGND sky130_ef_sc_hd__decap_12
Xclkbuf_leaf_23_clk clknet_3_2__leaf_clk VGND VGND VPWR VPWR clknet_leaf_23_clk sky130_fd_sc_hd__clkbuf_8
XFILLER_43_298 VGND VGND VPWR VPWR sky130_fd_sc_hd__decap_6
XFILLER_8_601 VPWR VGND VPWR VGND sky130_ef_sc_hd__decap_12
XFILLER_7_122 VGND VGND VPWR VPWR sky130_fd_sc_hd__decap_4
XFILLER_7_111 VGND VGND VPWR VPWR sky130_fd_sc_hd__fill_1
XFILLER_7_155 VGND VGND VPWR VPWR sky130_fd_sc_hd__decap_4
X_2200_ _1098_ _1684_ _1685_ _1679_ VGND VGND VPWR VPWR _0923_ sky130_fd_sc_hd__a2bb2o_1
XFILLER_78_162 VGND VGND VPWR VPWR sky130_fd_sc_hd__decap_3
X_3180_ net814 net338 net205 VGND VGND VPWR VPWR _0681_ sky130_fd_sc_hd__mux2_1
X_2131_ lsu.load_counter\[7\] _1619_ _1620_ lsu.load_counter\[6\] VGND VGND VPWR VPWR
+ _1621_ sky130_fd_sc_hd__o22a_1
X_2062_ net2 net13 VGND VGND VPWR VPWR _1552_ sky130_fd_sc_hd__nor2_1
XFILLER_66_346 VGND VGND VPWR VPWR sky130_fd_sc_hd__fill_2
XFILLER_19_273 VGND VGND VPWR VPWR sky130_fd_sc_hd__decap_6
XFILLER_62_541 VGND VGND VPWR VPWR sky130_fd_sc_hd__fill_1
XFILLER_34_287 VGND VGND VPWR VPWR sky130_fd_sc_hd__fill_1
X_2964_ net303 net1040 net216 VGND VGND VPWR VPWR _0475_ sky130_fd_sc_hd__mux2_1
Xclkbuf_leaf_14_clk clknet_3_3__leaf_clk VGND VGND VPWR VPWR clknet_leaf_14_clk sky130_fd_sc_hd__clkbuf_8
X_4703_ clknet_leaf_64_clk _0760_ VGND VGND VPWR VPWR lsu.store_fifo.queue\[14\]\[7\]
+ sky130_fd_sc_hd__dfxtp_1
X_2895_ net901 net309 net194 VGND VGND VPWR VPWR _0406_ sky130_fd_sc_hd__mux2_1
X_4634_ clknet_leaf_2_clk _0691_ VGND VGND VPWR VPWR lsu.load_fifo.queue\[15\]\[18\]
+ sky130_fd_sc_hd__dfxtp_1
Xhold612 lsu.store_fifo.queue\[6\]\[3\] VGND VGND VPWR VPWR net1080 sky130_fd_sc_hd__dlygate4sd3_1
Xhold601 lsu.store_fifo.queue\[1\]\[5\] VGND VGND VPWR VPWR net1069 sky130_fd_sc_hd__dlygate4sd3_1
X_4565_ clknet_leaf_2_clk _0622_ VGND VGND VPWR VPWR lsu.load_fifo.queue\[0\]\[13\]
+ sky130_fd_sc_hd__dfxtp_1
XFILLER_89_405 VGND VGND VPWR VPWR sky130_fd_sc_hd__decap_6
X_3516_ net436 VGND VGND VPWR VPWR _0080_ sky130_fd_sc_hd__inv_2
Xhold623 lsu.load_fifo.queue\[4\]\[25\] VGND VGND VPWR VPWR net1091 sky130_fd_sc_hd__dlygate4sd3_1
Xhold634 lsu.load_fifo.queue\[14\]\[18\] VGND VGND VPWR VPWR net1102 sky130_fd_sc_hd__dlygate4sd3_1
Xhold645 lsu.load_fifo.queue\[13\]\[8\] VGND VGND VPWR VPWR net1113 sky130_fd_sc_hd__dlygate4sd3_1
XTAP_TAPCELL_ROW_73_1037 VGND VPWR sky130_fd_sc_hd__tapvpwrvgnd_1
XPHY_EDGE_ROW_4_Right_4 VGND VGND VPWR VPWR sky130_fd_sc_hd__decap_3
Xhold667 lsu.store_fifo.queue\[0\]\[9\] VGND VGND VPWR VPWR net1135 sky130_fd_sc_hd__dlygate4sd3_1
Xhold656 lsu.store_fifo.queue\[0\]\[2\] VGND VGND VPWR VPWR net1124 sky130_fd_sc_hd__dlygate4sd3_1
X_4496_ clknet_leaf_34_clk _0553_ VGND VGND VPWR VPWR lsu.load_fifo.queue\[2\]\[8\]
+ sky130_fd_sc_hd__dfxtp_1
Xhold678 lsu.load_fifo.queue\[5\]\[0\] VGND VGND VPWR VPWR net1146 sky130_fd_sc_hd__dlygate4sd3_1
X_3447_ net429 VGND VGND VPWR VPWR _0011_ sky130_fd_sc_hd__inv_2
Xhold689 lsu.load_fifo.queue\[13\]\[26\] VGND VGND VPWR VPWR net1157 sky130_fd_sc_hd__dlygate4sd3_1
X_3378_ net301 net847 net170 VGND VGND VPWR VPWR _0987_ sky130_fd_sc_hd__mux2_1
X_2329_ _1107_ _0001_ _1106_ net1278 VGND VGND VPWR VPWR _0879_ sky130_fd_sc_hd__a2bb2o_1
XTAP_TAPCELL_ROW_84_1155 VGND VPWR sky130_fd_sc_hd__tapvpwrvgnd_1
XFILLER_13_405 VPWR VGND VPWR VGND sky130_ef_sc_hd__decap_12
XFILLER_13_449 VPWR VGND VPWR VGND sky130_ef_sc_hd__decap_12
XFILLER_40_224 VGND VGND VPWR VPWR sky130_fd_sc_hd__decap_3
XFILLER_43_57 VGND VGND VPWR VPWR sky130_fd_sc_hd__fill_1
Xclone12 net165 VGND VGND VPWR VPWR net480 sky130_fd_sc_hd__buf_6
XTAP_TAPCELL_ROW_23_488 VGND VPWR sky130_fd_sc_hd__tapvpwrvgnd_1
XTAP_TAPCELL_ROW_51_786 VGND VPWR sky130_fd_sc_hd__tapvpwrvgnd_1
XFILLER_5_615 VGND VGND VPWR VPWR sky130_fd_sc_hd__fill_1
XTAP_TAPCELL_ROW_95_1273 VGND VPWR sky130_fd_sc_hd__tapvpwrvgnd_1
XFILLER_4_29 VPWR VGND VPWR VGND sky130_ef_sc_hd__decap_12
XFILLER_84_53 VGND VGND VPWR VPWR sky130_fd_sc_hd__decap_4
XTAP_TAPCELL_ROW_59_875 VGND VPWR sky130_fd_sc_hd__tapvpwrvgnd_1
XFILLER_16_232 VGND VGND VPWR VPWR sky130_fd_sc_hd__fill_1
XFILLER_90_157 VPWR VGND VPWR VGND sky130_ef_sc_hd__decap_12
XFILLER_31_279 VGND VGND VPWR VPWR sky130_fd_sc_hd__fill_1
XFILLER_76_6 VGND VGND VPWR VPWR sky130_fd_sc_hd__decap_3
X_2680_ net678 net340 net233 VGND VGND VPWR VPWR _0204_ sky130_fd_sc_hd__mux2_1
XFILLER_8_475 VGND VGND VPWR VPWR sky130_fd_sc_hd__fill_1
X_4350_ clknet_leaf_32_clk _0407_ VGND VGND VPWR VPWR lsu.load_fifo.queue\[7\]\[24\]
+ sky130_fd_sc_hd__dfxtp_1
X_3301_ net323 net54 net251 VGND VGND VPWR VPWR _0863_ sky130_fd_sc_hd__mux2_1
X_4281_ clknet_leaf_8_clk _0338_ VGND VGND VPWR VPWR lsu.load_fifo.queue\[9\]\[19\]
+ sky130_fd_sc_hd__dfxtp_1
X_3232_ net753 lsu.current_load_addr\[4\] net237 VGND VGND VPWR VPWR _0770_ sky130_fd_sc_hd__mux2_1
Xclkbuf_leaf_3_clk clknet_3_0__leaf_clk VGND VGND VPWR VPWR clknet_leaf_3_clk sky130_fd_sc_hd__clkbuf_8
X_3163_ net553 net307 net180 VGND VGND VPWR VPWR _0665_ sky130_fd_sc_hd__mux2_1
X_2114_ lsu.load_counter\[11\] _1561_ _1600_ VGND VGND VPWR VPWR _1604_ sky130_fd_sc_hd__and3_1
XFILLER_81_102 VGND VGND VPWR VPWR sky130_fd_sc_hd__fill_1
X_3094_ net312 net1190 net187 VGND VGND VPWR VPWR _0598_ sky130_fd_sc_hd__mux2_1
XFILLER_81_146 VGND VGND VPWR VPWR sky130_fd_sc_hd__fill_1
XFILLER_22_213 VGND VGND VPWR VPWR sky130_fd_sc_hd__fill_1
X_3996_ lsu.load_fifo.queue\[12\]\[0\] lsu.load_fifo.queue\[13\]\[0\] lsu.load_fifo.queue\[14\]\[0\]
+ lsu.load_fifo.queue\[15\]\[0\] net397 net380 VGND VGND VPWR VPWR _1437_ sky130_fd_sc_hd__mux4_1
X_2947_ net336 net1201 net214 VGND VGND VPWR VPWR _0458_ sky130_fd_sc_hd__mux2_1
XTAP_TAPCELL_ROW_20_447 VGND VPWR sky130_fd_sc_hd__tapvpwrvgnd_1
X_2878_ net1100 net342 net193 VGND VGND VPWR VPWR _0389_ sky130_fd_sc_hd__mux2_1
X_4617_ clknet_leaf_78_clk _0674_ VGND VGND VPWR VPWR lsu.load_fifo.queue\[15\]\[1\]
+ sky130_fd_sc_hd__dfxtp_1
Xhold420 lsu.store_fifo.queue\[4\]\[7\] VGND VGND VPWR VPWR net888 sky130_fd_sc_hd__dlygate4sd3_1
XFILLER_104_513 VPWR VGND VPWR VGND sky130_ef_sc_hd__decap_12
Xhold453 lsu.load_fifo.queue\[2\]\[25\] VGND VGND VPWR VPWR net921 sky130_fd_sc_hd__dlygate4sd3_1
Xhold431 lsu.load_fifo.queue\[4\]\[26\] VGND VGND VPWR VPWR net899 sky130_fd_sc_hd__dlygate4sd3_1
Xhold442 lsu.load_fifo.queue\[11\]\[8\] VGND VGND VPWR VPWR net910 sky130_fd_sc_hd__dlygate4sd3_1
X_4548_ clknet_leaf_15_clk _0605_ VGND VGND VPWR VPWR lsu.load_fifo.queue\[1\]\[28\]
+ sky130_fd_sc_hd__dfxtp_1
Xhold486 _0780_ VGND VGND VPWR VPWR net954 sky130_fd_sc_hd__dlygate4sd3_1
X_4479_ clknet_leaf_80_clk _0536_ VGND VGND VPWR VPWR lsu.load_fifo.queue\[3\]\[23\]
+ sky130_fd_sc_hd__dfxtp_1
Xhold475 lsu.store_fifo.queue\[9\]\[2\] VGND VGND VPWR VPWR net943 sky130_fd_sc_hd__dlygate4sd3_1
Xhold464 lsu.load_fifo.queue\[6\]\[28\] VGND VGND VPWR VPWR net932 sky130_fd_sc_hd__dlygate4sd3_1
XFILLER_89_279 VGND VGND VPWR VPWR sky130_fd_sc_hd__fill_1
Xhold497 lsu.load_fifo.queue\[15\]\[18\] VGND VGND VPWR VPWR net965 sky130_fd_sc_hd__dlygate4sd3_1
XFILLER_85_452 VPWR VGND VPWR VGND sky130_ef_sc_hd__decap_12
XPHY_EDGE_ROW_79_Right_79 VGND VGND VPWR VPWR sky130_fd_sc_hd__decap_3
XFILLER_73_614 VGND VGND VPWR VPWR sky130_fd_sc_hd__fill_2
XFILLER_45_316 VGND VGND VPWR VPWR sky130_fd_sc_hd__fill_1
XFILLER_45_327 VGND VGND VPWR VPWR sky130_fd_sc_hd__decap_8
XFILLER_57_165 VGND VGND VPWR VPWR sky130_fd_sc_hd__decap_3
XFILLER_57_187 VGND VGND VPWR VPWR sky130_fd_sc_hd__fill_1
XFILLER_26_530 VGND VGND VPWR VPWR sky130_fd_sc_hd__fill_2
XTAP_TAPCELL_ROW_28_536 VGND VPWR sky130_fd_sc_hd__tapvpwrvgnd_1
XTAP_TAPCELL_ROW_56_845 VGND VPWR sky130_fd_sc_hd__tapvpwrvgnd_1
XFILLER_26_574 VPWR VGND VPWR VGND sky130_ef_sc_hd__decap_12
XFILLER_54_45 VGND VGND VPWR VPWR sky130_fd_sc_hd__decap_8
XTAP_TAPCELL_ROW_97_1302 VGND VPWR sky130_fd_sc_hd__tapvpwrvgnd_1
XPHY_EDGE_ROW_88_Right_88 VGND VGND VPWR VPWR sky130_fd_sc_hd__decap_3
XFILLER_95_205 VPWR VGND VPWR VGND sky130_ef_sc_hd__decap_12
XFILLER_68_419 VGND VGND VPWR VPWR sky130_fd_sc_hd__fill_1
XPHY_EDGE_ROW_97_Right_97 VGND VGND VPWR VPWR sky130_fd_sc_hd__decap_3
XFILLER_95_249 VPWR VGND VPWR VGND sky130_ef_sc_hd__decap_12
XFILLER_76_496 VPWR VGND VPWR VGND sky130_ef_sc_hd__decap_12
XFILLER_63_113 VGND VGND VPWR VPWR sky130_fd_sc_hd__decap_3
XFILLER_17_541 VPWR VGND VPWR VGND sky130_ef_sc_hd__decap_12
XFILLER_32_500 VGND VGND VPWR VPWR sky130_fd_sc_hd__decap_4
XFILLER_17_585 VPWR VGND VPWR VGND sky130_ef_sc_hd__decap_12
XFILLER_32_533 VGND VGND VPWR VPWR sky130_fd_sc_hd__decap_8
XFILLER_44_393 VPWR VGND VPWR VGND sky130_ef_sc_hd__decap_12
X_3850_ _1312_ _1309_ net357 VGND VGND VPWR VPWR _1313_ sky130_fd_sc_hd__mux2_1
X_3781_ net359 net417 VGND VGND VPWR VPWR _1253_ sky130_fd_sc_hd__xor2_2
X_2801_ net278 net795 _2032_ VGND VGND VPWR VPWR _0315_ sky130_fd_sc_hd__mux2_1
XFILLER_74_3 VGND VGND VPWR VPWR sky130_fd_sc_hd__fill_2
X_2732_ net282 net1199 net234 VGND VGND VPWR VPWR _0253_ sky130_fd_sc_hd__mux2_1
X_2663_ net547 net289 _2021_ VGND VGND VPWR VPWR _0188_ sky130_fd_sc_hd__mux2_1
X_2594_ lsu.current_load_addr\[4\] _1982_ net477 VGND VGND VPWR VPWR _0731_ sky130_fd_sc_hd__mux2_4
X_4402_ clknet_leaf_21_clk _0459_ VGND VGND VPWR VPWR lsu.load_fifo.queue\[5\]\[10\]
+ sky130_fd_sc_hd__dfxtp_1
X_4333_ clknet_leaf_33_clk _0390_ VGND VGND VPWR VPWR lsu.load_fifo.queue\[7\]\[7\]
+ sky130_fd_sc_hd__dfxtp_1
Xfanout229 _2033_ VGND VGND VPWR VPWR net229 sky130_fd_sc_hd__buf_2
X_4264_ clknet_leaf_21_clk _0321_ VGND VGND VPWR VPWR lsu.load_fifo.queue\[9\]\[2\]
+ sky130_fd_sc_hd__dfxtp_1
Xfanout207 _2043_ VGND VGND VPWR VPWR net207 sky130_fd_sc_hd__buf_2
Xfanout218 _2036_ VGND VGND VPWR VPWR net218 sky130_fd_sc_hd__buf_4
X_3215_ net272 net1215 _2049_ VGND VGND VPWR VPWR _0726_ sky130_fd_sc_hd__mux2_1
XFILLER_67_441 VGND VGND VPWR VPWR sky130_fd_sc_hd__decap_6
X_4195_ clknet_leaf_70_clk _0252_ VGND VGND VPWR VPWR lsu.store_fifo.queue\[7\]\[3\]
+ sky130_fd_sc_hd__dfxtp_1
X_3146_ net995 net340 net179 VGND VGND VPWR VPWR _0648_ sky130_fd_sc_hd__mux2_1
XFILLER_82_433 VPWR VGND VPWR VGND sky130_ef_sc_hd__decap_12
X_3077_ net347 net1055 net187 VGND VGND VPWR VPWR _0581_ sky130_fd_sc_hd__mux2_1
XTAP_TAPCELL_ROW_25_506 VGND VPWR sky130_fd_sc_hd__tapvpwrvgnd_1
XTAP_TAPCELL_ROW_53_815 VGND VPWR sky130_fd_sc_hd__tapvpwrvgnd_1
XTAP_TAPCELL_ROW_81_1125 VGND VPWR sky130_fd_sc_hd__tapvpwrvgnd_1
XFILLER_24_48 VGND VGND VPWR VPWR sky130_fd_sc_hd__decap_8
X_3979_ lsu.load_fifo.queue\[8\]\[3\] lsu.load_fifo.queue\[9\]\[3\] lsu.load_fifo.queue\[10\]\[3\]
+ lsu.load_fifo.queue\[11\]\[3\] net383 net366 VGND VGND VPWR VPWR _1423_ sky130_fd_sc_hd__mux4_1
XTAP_TAPCELL_ROW_33_594 VGND VPWR sky130_fd_sc_hd__tapvpwrvgnd_1
XTAP_TAPCELL_ROW_79_1098 VGND VPWR sky130_fd_sc_hd__tapvpwrvgnd_1
XTAP_TAPCELL_ROW_92_1243 VGND VPWR sky130_fd_sc_hd__tapvpwrvgnd_1
Xhold261 lsu.load_fifo.queue\[9\]\[0\] VGND VGND VPWR VPWR net729 sky130_fd_sc_hd__dlygate4sd3_1
Xhold250 lsu.load_fifo.queue\[15\]\[30\] VGND VGND VPWR VPWR net718 sky130_fd_sc_hd__dlygate4sd3_1
Xhold294 lsu.load_fifo.queue\[15\]\[9\] VGND VGND VPWR VPWR net762 sky130_fd_sc_hd__dlygate4sd3_1
Xhold283 lsu.store_fifo.queue\[13\]\[1\] VGND VGND VPWR VPWR net751 sky130_fd_sc_hd__dlygate4sd3_1
Xhold272 lsu.load_fifo.queue\[4\]\[12\] VGND VGND VPWR VPWR net740 sky130_fd_sc_hd__dlygate4sd3_1
XFILLER_73_400 VPWR VGND VPWR VGND sky130_ef_sc_hd__decap_12
XTAP_TAPCELL_ROW_5_286 VGND VPWR sky130_fd_sc_hd__tapvpwrvgnd_1
XTAP_TAPCELL_ROW_69_992 VGND VPWR sky130_fd_sc_hd__tapvpwrvgnd_1
XFILLER_26_382 VPWR VGND VPWR VGND sky130_ef_sc_hd__decap_12
XFILLER_14_533 VPWR VGND VPWR VGND sky130_ef_sc_hd__decap_12
XFILLER_60_149 VGND VGND VPWR VPWR sky130_fd_sc_hd__decap_3
XFILLER_5_253 VGND VGND VPWR VPWR sky130_fd_sc_hd__decap_6
XFILLER_5_275 VGND VGND VPWR VPWR sky130_fd_sc_hd__decap_4
XFILLER_30_91 VGND VGND VPWR VPWR sky130_fd_sc_hd__fill_1
XFILLER_96_547 VGND VGND VPWR VPWR sky130_fd_sc_hd__decap_4
XFILLER_96_525 VGND VGND VPWR VPWR sky130_fd_sc_hd__decap_6
Xinput7 count[14] VGND VGND VPWR VPWR net7 sky130_fd_sc_hd__buf_1
X_3000_ net598 net300 net190 VGND VGND VPWR VPWR _0508_ sky130_fd_sc_hd__mux2_1
XFILLER_17_371 VPWR VGND VPWR VGND sky130_ef_sc_hd__decap_12
X_4951_ clknet_leaf_6_clk _1006_ _0137_ VGND VGND VPWR VPWR acc.byte0\[4\] sky130_fd_sc_hd__dfrtp_1
X_4882_ clknet_leaf_83_clk _0937_ VGND VGND VPWR VPWR lsu.load_fifo.queue\[12\]\[9\]
+ sky130_fd_sc_hd__dfxtp_1
XFILLER_17_393 VPWR VGND VPWR VGND sky130_ef_sc_hd__decap_12
X_3902_ _1354_ _1356_ _1353_ _1355_ net356 net362 VGND VGND VPWR VPWR _1357_ sky130_fd_sc_hd__mux4_1
XFILLER_51_149 VGND VGND VPWR VPWR sky130_fd_sc_hd__fill_2
X_3833_ lsu.load_fifo.queue\[8\]\[24\] lsu.load_fifo.queue\[9\]\[24\] lsu.load_fifo.queue\[10\]\[24\]
+ lsu.load_fifo.queue\[11\]\[24\] net397 net380 VGND VGND VPWR VPWR _1298_ sky130_fd_sc_hd__mux4_1
XFILLER_32_352 VGND VGND VPWR VPWR sky130_fd_sc_hd__fill_1
XTAP_TAPCELL_ROW_30_564 VGND VPWR sky130_fd_sc_hd__tapvpwrvgnd_1
X_3764_ _1205_ _1222_ VGND VGND VPWR VPWR _1240_ sky130_fd_sc_hd__xnor2_1
X_2715_ net273 net714 _2023_ VGND VGND VPWR VPWR _0238_ sky130_fd_sc_hd__mux2_1
X_3695_ _1174_ _1176_ _1173_ VGND VGND VPWR VPWR _1177_ sky130_fd_sc_hd__a21boi_1
X_2646_ _2012_ _2018_ VGND VGND VPWR VPWR _0705_ sky130_fd_sc_hd__and2_1
X_2577_ lsu.current_load_addr\[8\] _1924_ VGND VGND VPWR VPWR _1970_ sky130_fd_sc_hd__xnor2_1
XFILLER_99_341 VGND VGND VPWR VPWR sky130_fd_sc_hd__fill_1
X_4316_ clknet_leaf_72_clk _0373_ VGND VGND VPWR VPWR lsu.load_fifo.queue\[10\]\[22\]
+ sky130_fd_sc_hd__dfxtp_1
X_4247_ clknet_leaf_58_clk _0304_ VGND VGND VPWR VPWR lsu.store_fifo.queue\[2\]\[5\]
+ sky130_fd_sc_hd__dfxtp_1
X_4178_ clknet_leaf_50_clk _0235_ VGND VGND VPWR VPWR lsu.store_fifo.queue\[9\]\[6\]
+ sky130_fd_sc_hd__dfxtp_1
XTAP_TAPCELL_ROW_2_256 VGND VPWR sky130_fd_sc_hd__tapvpwrvgnd_1
XFILLER_27_113 VGND VGND VPWR VPWR sky130_fd_sc_hd__decap_4
X_3129_ net1060 net308 net182 VGND VGND VPWR VPWR _0632_ sky130_fd_sc_hd__mux2_1
XFILLER_27_146 VGND VGND VPWR VPWR sky130_fd_sc_hd__decap_6
XTAP_TAPCELL_ROW_38_653 VGND VPWR sky130_fd_sc_hd__tapvpwrvgnd_1
XFILLER_43_617 VGND VGND VPWR VPWR sky130_fd_sc_hd__fill_1
XTAP_TAPCELL_ROW_66_951 VGND VPWR sky130_fd_sc_hd__tapvpwrvgnd_1
XFILLER_70_469 VGND VGND VPWR VPWR sky130_fd_sc_hd__decap_6
XFILLER_11_503 VGND VGND VPWR VPWR sky130_fd_sc_hd__fill_1
XFILLER_51_24 VGND VGND VPWR VPWR sky130_fd_sc_hd__fill_1
XFILLER_7_529 VPWR VGND VPWR VGND sky130_ef_sc_hd__decap_12
XFILLER_51_57 VGND VGND VPWR VPWR sky130_fd_sc_hd__decap_3
XFILLER_51_68 VGND VGND VPWR VPWR sky130_fd_sc_hd__fill_1
XFILLER_2_201 VGND VGND VPWR VPWR sky130_fd_sc_hd__fill_1
XFILLER_4_3 VPWR VGND VPWR VGND sky130_ef_sc_hd__decap_12
XFILLER_2_278 VGND VGND VPWR VPWR sky130_fd_sc_hd__decap_3
XFILLER_92_53 VPWR VGND VPWR VGND sky130_ef_sc_hd__decap_12
XFILLER_34_628 VGND VGND VPWR VPWR sky130_fd_sc_hd__fill_2
XFILLER_92_97 VPWR VGND VPWR VGND sky130_ef_sc_hd__decap_12
XFILLER_61_447 VGND VGND VPWR VPWR sky130_fd_sc_hd__fill_1
X_2500_ net102 net267 _1717_ VGND VGND VPWR VPWR _1912_ sky130_fd_sc_hd__o21a_1
X_3480_ net440 VGND VGND VPWR VPWR _0044_ sky130_fd_sc_hd__inv_2
X_2431_ lsu.current_store_addr\[18\] _1854_ VGND VGND VPWR VPWR _1864_ sky130_fd_sc_hd__nor2_1
X_2362_ _1797_ _1798_ _1800_ VGND VGND VPWR VPWR _1801_ sky130_fd_sc_hd__nor3_1
XFILLER_37_3 VGND VGND VPWR VPWR sky130_fd_sc_hd__fill_2
XFILLER_96_333 VGND VGND VPWR VPWR sky130_fd_sc_hd__decap_8
X_2293_ _1720_ _1731_ VGND VGND VPWR VPWR _1750_ sky130_fd_sc_hd__and2_1
X_4101_ lsu.store_fifo.queue\[12\]\[1\] lsu.store_fifo.queue\[13\]\[1\] lsu.store_fifo.queue\[14\]\[1\]
+ lsu.store_fifo.queue\[15\]\[1\] net412 net407 VGND VGND VPWR VPWR _1533_ sky130_fd_sc_hd__mux4_1
X_4032_ lsu.store_fifo.queue\[8\]\[7\] lsu.store_fifo.queue\[9\]\[7\] lsu.store_fifo.queue\[10\]\[7\]
+ lsu.store_fifo.queue\[11\]\[7\] net412 net407 VGND VGND VPWR VPWR _1470_ sky130_fd_sc_hd__mux4_1
XFILLER_84_539 VGND VGND VPWR VPWR sky130_fd_sc_hd__decap_8
XFILLER_25_617 VGND VGND VPWR VPWR sky130_fd_sc_hd__fill_1
XTAP_TAPCELL_ROW_35_612 VGND VPWR sky130_fd_sc_hd__tapvpwrvgnd_1
XTAP_TAPCELL_ROW_63_921 VGND VPWR sky130_fd_sc_hd__tapvpwrvgnd_1
X_4934_ clknet_leaf_23_clk _0989_ VGND VGND VPWR VPWR lsu.load_fifo.queue\[13\]\[29\]
+ sky130_fd_sc_hd__dfxtp_1
XFILLER_52_469 VGND VGND VPWR VPWR sky130_fd_sc_hd__decap_6
X_4865_ clknet_leaf_42_clk _0920_ _0115_ VGND VGND VPWR VPWR lsu.load_counter\[15\]
+ sky130_fd_sc_hd__dfrtp_1
XTAP_TAPCELL_ROW_15_391 VGND VPWR sky130_fd_sc_hd__tapvpwrvgnd_1
X_4796_ clknet_leaf_0_clk _0853_ VGND VGND VPWR VPWR lsu.load_fifo.data_in\[6\] sky130_fd_sc_hd__dfxtp_1
X_3816_ lsu.load_fifo.queue\[4\]\[26\] lsu.load_fifo.queue\[5\]\[26\] lsu.load_fifo.queue\[6\]\[26\]
+ lsu.load_fifo.queue\[7\]\[26\] net392 net375 VGND VGND VPWR VPWR _1283_ sky130_fd_sc_hd__mux4_1
X_3747_ _1180_ _1228_ VGND VGND VPWR VPWR _1229_ sky130_fd_sc_hd__nand2_1
X_3678_ _1157_ _1159_ _1156_ VGND VGND VPWR VPWR _1160_ sky130_fd_sc_hd__a21boi_1
Xoutput130 net130 VGND VGND VPWR VPWR store_addr[12] sky130_fd_sc_hd__buf_2
X_2629_ _1997_ _2005_ VGND VGND VPWR VPWR _0709_ sky130_fd_sc_hd__and2_1
XTAP_TAPCELL_ROW_76_1068 VGND VPWR sky130_fd_sc_hd__tapvpwrvgnd_1
XTAP_TAPCELL_ROW_7_304 VGND VPWR sky130_fd_sc_hd__tapvpwrvgnd_1
Xoutput152 net152 VGND VGND VPWR VPWR store_data[3] sky130_fd_sc_hd__buf_2
Xoutput141 net141 VGND VGND VPWR VPWR store_addr[2] sky130_fd_sc_hd__buf_2
XFILLER_101_154 VGND VGND VPWR VPWR sky130_fd_sc_hd__fill_1
XFILLER_75_517 VGND VGND VPWR VPWR sky130_fd_sc_hd__decap_6
XFILLER_83_561 VGND VGND VPWR VPWR sky130_fd_sc_hd__fill_2
XTAP_TAPCELL_ROW_87_1186 VGND VPWR sky130_fd_sc_hd__tapvpwrvgnd_1
XFILLER_102_41 VPWR VGND VPWR VGND sky130_ef_sc_hd__decap_12
XFILLER_102_85 VGND VGND VPWR VPWR sky130_fd_sc_hd__decap_8
XFILLER_105_482 VGND VGND VPWR VPWR sky130_fd_sc_hd__decap_8
XFILLER_78_322 VGND VGND VPWR VPWR sky130_fd_sc_hd__fill_1
XFILLER_87_97 VPWR VGND VPWR VGND sky130_ef_sc_hd__decap_12
XFILLER_23_9 VGND VGND VPWR VPWR sky130_fd_sc_hd__fill_2
Xfanout390 net399 VGND VGND VPWR VPWR net390 sky130_fd_sc_hd__buf_2
XFILLER_61_222 VGND VGND VPWR VPWR sky130_fd_sc_hd__fill_2
X_2980_ net589 net341 net192 VGND VGND VPWR VPWR _0488_ sky130_fd_sc_hd__mux2_1
X_4650_ clknet_leaf_51_clk _0707_ _0006_ VGND VGND VPWR VPWR lsu.store_fifo.w_ptr\[2\]
+ sky130_fd_sc_hd__dfrtp_2
Xinput10 count[17] VGND VGND VPWR VPWR net10 sky130_fd_sc_hd__clkbuf_1
Xinput21 count[7] VGND VGND VPWR VPWR net21 sky130_fd_sc_hd__buf_1
XTAP_TAPCELL_ROW_12_361 VGND VPWR sky130_fd_sc_hd__tapvpwrvgnd_1
XTAP_TAPCELL_ROW_40_670 VGND VPWR sky130_fd_sc_hd__tapvpwrvgnd_1
X_3601_ net434 VGND VGND VPWR VPWR _0165_ sky130_fd_sc_hd__inv_2
Xinput43 load_base_addr[7] VGND VGND VPWR VPWR net43 sky130_fd_sc_hd__clkbuf_1
Xinput54 load_data[16] VGND VGND VPWR VPWR net54 sky130_fd_sc_hd__buf_1
Xinput32 load_base_addr[17] VGND VGND VPWR VPWR net32 sky130_fd_sc_hd__buf_1
X_4581_ clknet_leaf_23_clk _0638_ VGND VGND VPWR VPWR lsu.load_fifo.queue\[0\]\[29\]
+ sky130_fd_sc_hd__dfxtp_1
Xinput76 load_data[7] VGND VGND VPWR VPWR net76 sky130_fd_sc_hd__clkbuf_1
Xhold816 lsu.current_load_addr\[21\] VGND VGND VPWR VPWR net1284 sky130_fd_sc_hd__dlygate4sd3_1
Xinput87 store_base_addr[16] VGND VGND VPWR VPWR net87 sky130_fd_sc_hd__clkbuf_1
Xinput98 store_base_addr[6] VGND VGND VPWR VPWR net98 sky130_fd_sc_hd__clkbuf_1
X_3532_ net439 VGND VGND VPWR VPWR _0096_ sky130_fd_sc_hd__inv_2
Xinput65 load_data[26] VGND VGND VPWR VPWR net65 sky130_fd_sc_hd__clkbuf_1
Xhold805 acc.byte1\[4\] VGND VGND VPWR VPWR net1273 sky130_fd_sc_hd__dlygate4sd3_1
Xhold827 acc.byte0\[7\] VGND VGND VPWR VPWR net1295 sky130_fd_sc_hd__dlygate4sd3_1
X_3463_ net426 VGND VGND VPWR VPWR _0027_ sky130_fd_sc_hd__inv_2
Xhold838 lsu.load_counter\[3\] VGND VGND VPWR VPWR net1306 sky130_fd_sc_hd__dlygate4sd3_1
X_2414_ _1849_ VGND VGND VPWR VPWR _1850_ sky130_fd_sc_hd__inv_2
X_3394_ net1015 net334 net200 VGND VGND VPWR VPWR _1044_ sky130_fd_sc_hd__mux2_1
XFILLER_69_333 VGND VGND VPWR VPWR sky130_fd_sc_hd__decap_3
XFILLER_96_141 VPWR VGND VPWR VGND sky130_ef_sc_hd__decap_12
X_2345_ lsu.store_counter\[18\] _1574_ _1783_ _1782_ VGND VGND VPWR VPWR _1784_ sky130_fd_sc_hd__a211o_1
X_2276_ _1737_ _1739_ VGND VGND VPWR VPWR _0901_ sky130_fd_sc_hd__and2_1
XFILLER_84_347 VPWR VGND VPWR VGND sky130_ef_sc_hd__decap_12
X_4015_ net400 _1452_ net403 VGND VGND VPWR VPWR _1455_ sky130_fd_sc_hd__o21ai_1
XFILLER_80_553 VGND VGND VPWR VPWR sky130_fd_sc_hd__decap_8
XFILLER_13_609 VGND VGND VPWR VPWR sky130_fd_sc_hd__decap_6
XFILLER_33_480 VGND VGND VPWR VPWR sky130_fd_sc_hd__fill_1
X_4917_ clknet_leaf_19_clk _0972_ VGND VGND VPWR VPWR lsu.load_fifo.queue\[13\]\[12\]
+ sky130_fd_sc_hd__dfxtp_1
X_4848_ clknet_leaf_35_clk _0904_ _0098_ VGND VGND VPWR VPWR lsu.acc_state\[1\] sky130_fd_sc_hd__dfrtp_1
XFILLER_20_141 VGND VGND VPWR VPWR sky130_fd_sc_hd__fill_2
X_4779_ clknet_leaf_38_clk _0836_ _0071_ VGND VGND VPWR VPWR net126 sky130_fd_sc_hd__dfrtp_1
XFILLER_20_185 VGND VGND VPWR VPWR sky130_fd_sc_hd__decap_3
XFILLER_106_6 VPWR VGND VPWR VGND sky130_ef_sc_hd__decap_12
XFILLER_106_268 VGND VGND VPWR VPWR sky130_fd_sc_hd__fill_1
XTAP_TAPCELL_ROW_89_1204 VGND VPWR sky130_fd_sc_hd__tapvpwrvgnd_1
XFILLER_57_23 VGND VGND VPWR VPWR sky130_fd_sc_hd__decap_3
XFILLER_48_528 VGND VGND VPWR VPWR sky130_fd_sc_hd__decap_4
XFILLER_75_358 VPWR VGND VPWR VGND sky130_ef_sc_hd__decap_12
XFILLER_83_391 VGND VGND VPWR VPWR sky130_fd_sc_hd__fill_1
XFILLER_43_222 VGND VGND VPWR VPWR sky130_fd_sc_hd__fill_2
XFILLER_16_469 VGND VGND VPWR VPWR sky130_fd_sc_hd__decap_6
XFILLER_31_428 VGND VGND VPWR VPWR sky130_fd_sc_hd__decap_8
XFILLER_8_613 VPWR VGND VPWR VGND sky130_ef_sc_hd__decap_12
XFILLER_98_41 VPWR VGND VPWR VGND sky130_ef_sc_hd__decap_12
XFILLER_98_85 VPWR VGND VPWR VGND sky130_ef_sc_hd__decap_12
X_2130_ net20 _1617_ VGND VGND VPWR VPWR _1620_ sky130_fd_sc_hd__xor2_2
XFILLER_93_111 VGND VGND VPWR VPWR sky130_fd_sc_hd__fill_1
X_2061_ _1116_ _1117_ net79 _1550_ VGND VGND VPWR VPWR _1551_ sky130_fd_sc_hd__a31o_1
XTAP_TAPCELL_ROW_17_420 VGND VPWR sky130_fd_sc_hd__tapvpwrvgnd_1
XFILLER_62_531 VGND VGND VPWR VPWR sky130_fd_sc_hd__fill_1
X_2963_ net305 net1231 net215 VGND VGND VPWR VPWR _0474_ sky130_fd_sc_hd__mux2_1
X_4702_ clknet_leaf_50_clk _0759_ VGND VGND VPWR VPWR lsu.store_fifo.queue\[14\]\[6\]
+ sky130_fd_sc_hd__dfxtp_1
X_2894_ net1008 net310 net194 VGND VGND VPWR VPWR _0405_ sky130_fd_sc_hd__mux2_1
X_4633_ clknet_leaf_69_clk _0690_ VGND VGND VPWR VPWR lsu.load_fifo.queue\[15\]\[17\]
+ sky130_fd_sc_hd__dfxtp_1
XFILLER_30_494 VGND VGND VPWR VPWR sky130_fd_sc_hd__fill_1
Xhold602 lsu.load_fifo.queue\[7\]\[8\] VGND VGND VPWR VPWR net1070 sky130_fd_sc_hd__dlygate4sd3_1
X_4564_ clknet_leaf_17_clk _0621_ VGND VGND VPWR VPWR lsu.load_fifo.queue\[0\]\[12\]
+ sky130_fd_sc_hd__dfxtp_1
Xhold613 lsu.load_fifo.queue\[9\]\[21\] VGND VGND VPWR VPWR net1081 sky130_fd_sc_hd__dlygate4sd3_1
X_3515_ net436 VGND VGND VPWR VPWR _0079_ sky130_fd_sc_hd__inv_2
Xhold635 lsu.load_fifo.queue\[10\]\[23\] VGND VGND VPWR VPWR net1103 sky130_fd_sc_hd__dlygate4sd3_1
Xhold624 lsu.store_fifo.queue\[3\]\[7\] VGND VGND VPWR VPWR net1092 sky130_fd_sc_hd__dlygate4sd3_1
Xhold679 lsu.load_fifo.queue\[1\]\[24\] VGND VGND VPWR VPWR net1147 sky130_fd_sc_hd__dlygate4sd3_1
X_4495_ clknet_leaf_32_clk _0552_ VGND VGND VPWR VPWR lsu.load_fifo.queue\[2\]\[7\]
+ sky130_fd_sc_hd__dfxtp_1
XTAP_TAPCELL_ROW_73_1038 VGND VPWR sky130_fd_sc_hd__tapvpwrvgnd_1
Xhold646 lsu.load_fifo.queue\[9\]\[25\] VGND VGND VPWR VPWR net1114 sky130_fd_sc_hd__dlygate4sd3_1
Xhold657 lsu.load_fifo.queue\[10\]\[26\] VGND VGND VPWR VPWR net1125 sky130_fd_sc_hd__dlygate4sd3_1
Xhold668 lsu.store_fifo.queue\[13\]\[0\] VGND VGND VPWR VPWR net1136 sky130_fd_sc_hd__dlygate4sd3_1
X_3446_ net429 VGND VGND VPWR VPWR _0010_ sky130_fd_sc_hd__inv_2
X_3377_ net302 net1157 net171 VGND VGND VPWR VPWR _0986_ sky130_fd_sc_hd__mux2_1
X_2328_ lsu.acc_state\[0\] net1294 lsu.acc_state\[1\] VGND VGND VPWR VPWR _0001_ sky130_fd_sc_hd__and3b_1
XFILLER_84_188 VGND VGND VPWR VPWR sky130_fd_sc_hd__decap_8
X_2259_ _1716_ _1721_ _1717_ VGND VGND VPWR VPWR _1724_ sky130_fd_sc_hd__a21bo_1
XFILLER_72_306 VGND VGND VPWR VPWR sky130_fd_sc_hd__fill_2
XFILLER_65_391 VGND VGND VPWR VPWR sky130_fd_sc_hd__fill_1
XTAP_TAPCELL_ROW_84_1156 VGND VPWR sky130_fd_sc_hd__tapvpwrvgnd_1
XFILLER_13_417 VPWR VGND VPWR VGND sky130_ef_sc_hd__decap_12
XFILLER_25_277 VGND VGND VPWR VPWR sky130_fd_sc_hd__decap_3
XFILLER_40_236 VGND VGND VPWR VPWR sky130_fd_sc_hd__fill_2
XTAP_TAPCELL_ROW_23_478 VGND VPWR sky130_fd_sc_hd__tapvpwrvgnd_1
XTAP_TAPCELL_ROW_51_787 VGND VPWR sky130_fd_sc_hd__tapvpwrvgnd_1
XTAP_TAPCELL_ROW_95_1274 VGND VPWR sky130_fd_sc_hd__tapvpwrvgnd_1
XFILLER_68_22 VGND VGND VPWR VPWR sky130_fd_sc_hd__decap_6
XFILLER_0_365 VPWR VGND VPWR VGND sky130_ef_sc_hd__decap_12
XFILLER_91_615 VGND VGND VPWR VPWR sky130_fd_sc_hd__fill_1
XTAP_TAPCELL_ROW_59_876 VGND VPWR sky130_fd_sc_hd__tapvpwrvgnd_1
XFILLER_90_169 VPWR VGND VPWR VGND sky130_ef_sc_hd__decap_12
XFILLER_17_92 VGND VGND VPWR VPWR sky130_fd_sc_hd__decap_4
XFILLER_31_225 VGND VGND VPWR VPWR sky130_fd_sc_hd__fill_2
XTAP_TAPCELL_ROW_104_1370 VGND VPWR sky130_fd_sc_hd__tapvpwrvgnd_1
XFILLER_8_421 VPWR VGND VPWR VGND sky130_ef_sc_hd__decap_12
X_3300_ net324 net53 net250 VGND VGND VPWR VPWR _0862_ sky130_fd_sc_hd__mux2_1
X_4280_ clknet_leaf_84_clk _0337_ VGND VGND VPWR VPWR lsu.load_fifo.queue\[9\]\[18\]
+ sky130_fd_sc_hd__dfxtp_1
X_3231_ net854 lsu.current_load_addr\[3\] net237 VGND VGND VPWR VPWR _0769_ sky130_fd_sc_hd__mux2_1
XFILLER_98_269 VGND VGND VPWR VPWR sky130_fd_sc_hd__fill_1
X_3162_ net637 net308 net178 VGND VGND VPWR VPWR _0664_ sky130_fd_sc_hd__mux2_1
X_2113_ lsu.load_counter\[11\] _1601_ VGND VGND VPWR VPWR _1603_ sky130_fd_sc_hd__or2_1
XFILLER_66_133 VGND VGND VPWR VPWR sky130_fd_sc_hd__decap_6
XFILLER_94_475 VGND VGND VPWR VPWR sky130_fd_sc_hd__fill_1
X_3093_ net314 net935 net185 VGND VGND VPWR VPWR _0597_ sky130_fd_sc_hd__mux2_1
XFILLER_47_391 VGND VGND VPWR VPWR sky130_fd_sc_hd__fill_1
X_3995_ lsu.load_fifo.queue\[0\]\[0\] lsu.load_fifo.queue\[1\]\[0\] lsu.load_fifo.queue\[2\]\[0\]
+ lsu.load_fifo.queue\[3\]\[0\] net397 net380 VGND VGND VPWR VPWR _1436_ sky130_fd_sc_hd__mux4_1
X_2946_ net338 net766 net217 VGND VGND VPWR VPWR _0457_ sky130_fd_sc_hd__mux2_1
XTAP_TAPCELL_ROW_20_448 VGND VPWR sky130_fd_sc_hd__tapvpwrvgnd_1
X_2877_ net940 net344 net195 VGND VGND VPWR VPWR _0388_ sky130_fd_sc_hd__mux2_1
X_4616_ clknet_leaf_32_clk _0673_ VGND VGND VPWR VPWR lsu.load_fifo.queue\[15\]\[0\]
+ sky130_fd_sc_hd__dfxtp_1
Xhold410 lsu.store_fifo.queue\[1\]\[3\] VGND VGND VPWR VPWR net878 sky130_fd_sc_hd__dlygate4sd3_1
Xhold454 net136 VGND VGND VPWR VPWR net922 sky130_fd_sc_hd__dlygate4sd3_1
Xhold443 lsu.load_fifo.queue\[6\]\[29\] VGND VGND VPWR VPWR net911 sky130_fd_sc_hd__dlygate4sd3_1
X_4547_ clknet_leaf_81_clk _0604_ VGND VGND VPWR VPWR lsu.load_fifo.queue\[1\]\[27\]
+ sky130_fd_sc_hd__dfxtp_1
Xhold421 lsu.load_fifo.queue\[4\]\[13\] VGND VGND VPWR VPWR net889 sky130_fd_sc_hd__dlygate4sd3_1
Xhold432 lsu.load_fifo.queue\[6\]\[4\] VGND VGND VPWR VPWR net900 sky130_fd_sc_hd__dlygate4sd3_1
XFILLER_104_525 VGND VGND VPWR VPWR sky130_fd_sc_hd__decap_4
XFILLER_89_225 VPWR VGND VPWR VGND sky130_ef_sc_hd__decap_12
Xhold476 lsu.load_fifo.queue\[1\]\[29\] VGND VGND VPWR VPWR net944 sky130_fd_sc_hd__dlygate4sd3_1
Xhold465 lsu.load_fifo.queue\[6\]\[24\] VGND VGND VPWR VPWR net933 sky130_fd_sc_hd__dlygate4sd3_1
Xhold487 lsu.store_fifo.queue\[11\]\[3\] VGND VGND VPWR VPWR net955 sky130_fd_sc_hd__dlygate4sd3_1
X_4478_ clknet_leaf_72_clk _0535_ VGND VGND VPWR VPWR lsu.load_fifo.queue\[3\]\[22\]
+ sky130_fd_sc_hd__dfxtp_1
X_3429_ net686 net289 _2059_ VGND VGND VPWR VPWR _1087_ sky130_fd_sc_hd__mux2_1
Xhold498 lsu.load_fifo.queue\[14\]\[13\] VGND VGND VPWR VPWR net966 sky130_fd_sc_hd__dlygate4sd3_1
XFILLER_38_25 VGND VGND VPWR VPWR sky130_fd_sc_hd__decap_3
XFILLER_38_69 VGND VGND VPWR VPWR sky130_fd_sc_hd__decap_6
XFILLER_18_509 VPWR VGND VPWR VGND sky130_ef_sc_hd__decap_12
XFILLER_45_306 VGND VGND VPWR VPWR sky130_fd_sc_hd__decap_4
XTAP_TAPCELL_ROW_28_537 VGND VPWR sky130_fd_sc_hd__tapvpwrvgnd_1
XTAP_TAPCELL_ROW_56_846 VGND VPWR sky130_fd_sc_hd__tapvpwrvgnd_1
XFILLER_26_553 VGND VGND VPWR VPWR sky130_fd_sc_hd__fill_1
XFILLER_13_225 VGND VGND VPWR VPWR sky130_fd_sc_hd__fill_2
XFILLER_26_586 VGND VGND VPWR VPWR sky130_fd_sc_hd__fill_2
XFILLER_41_501 VGND VGND VPWR VPWR sky130_fd_sc_hd__decap_3
XFILLER_54_79 VGND VGND VPWR VPWR sky130_fd_sc_hd__decap_4
XFILLER_95_217 VGND VGND VPWR VPWR sky130_fd_sc_hd__decap_6
XFILLER_0_195 VGND VGND VPWR VPWR sky130_fd_sc_hd__fill_1
XTAP_TAPCELL_ROW_106_1410 VGND VPWR sky130_fd_sc_hd__tapvpwrvgnd_1
XFILLER_48_188 VGND VGND VPWR VPWR sky130_fd_sc_hd__decap_8
XFILLER_17_553 VGND VGND VPWR VPWR sky130_fd_sc_hd__decap_6
XFILLER_17_597 VPWR VGND VPWR VGND sky130_ef_sc_hd__decap_12
XPHY_EDGE_ROW_4_Left_111 VGND VGND VPWR VPWR sky130_fd_sc_hd__decap_3
X_3780_ net356 _1251_ VGND VGND VPWR VPWR _1252_ sky130_fd_sc_hd__and2b_1
X_2800_ net280 net1069 _2032_ VGND VGND VPWR VPWR _0314_ sky130_fd_sc_hd__mux2_1
XFILLER_12_280 VPWR VGND VPWR VGND sky130_ef_sc_hd__decap_12
X_2731_ net284 net1112 net234 VGND VGND VPWR VPWR _0252_ sky130_fd_sc_hd__mux2_1
XFILLER_8_262 VGND VGND VPWR VPWR sky130_fd_sc_hd__decap_4
X_4401_ clknet_leaf_82_clk _0458_ VGND VGND VPWR VPWR lsu.load_fifo.queue\[5\]\[9\]
+ sky130_fd_sc_hd__dfxtp_1
X_2662_ net520 net291 _2021_ VGND VGND VPWR VPWR _0187_ sky130_fd_sc_hd__mux2_1
X_2593_ net264 _1922_ _1980_ _1981_ VGND VGND VPWR VPWR _1982_ sky130_fd_sc_hd__a31o_1
X_4332_ clknet_leaf_87_clk _0389_ VGND VGND VPWR VPWR lsu.load_fifo.queue\[7\]\[6\]
+ sky130_fd_sc_hd__dfxtp_1
Xfanout208 _2043_ VGND VGND VPWR VPWR net208 sky130_fd_sc_hd__buf_4
X_4263_ clknet_leaf_77_clk _0320_ VGND VGND VPWR VPWR lsu.load_fifo.queue\[9\]\[1\]
+ sky130_fd_sc_hd__dfxtp_1
Xfanout219 _2036_ VGND VGND VPWR VPWR net219 sky130_fd_sc_hd__buf_2
X_3214_ net274 net1020 _2049_ VGND VGND VPWR VPWR _0725_ sky130_fd_sc_hd__mux2_1
XFILLER_39_111 VGND VGND VPWR VPWR sky130_fd_sc_hd__fill_1
X_4194_ clknet_leaf_58_clk _0251_ VGND VGND VPWR VPWR lsu.store_fifo.queue\[7\]\[2\]
+ sky130_fd_sc_hd__dfxtp_1
X_3145_ net992 net343 net177 VGND VGND VPWR VPWR _0647_ sky130_fd_sc_hd__mux2_1
XFILLER_39_144 VGND VGND VPWR VPWR sky130_fd_sc_hd__decap_6
XFILLER_82_445 VPWR VGND VPWR VGND sky130_ef_sc_hd__decap_12
X_3076_ net349 net1221 net185 VGND VGND VPWR VPWR _0580_ sky130_fd_sc_hd__mux2_1
XFILLER_54_158 VGND VGND VPWR VPWR sky130_fd_sc_hd__fill_1
XFILLER_23_523 VGND VGND VPWR VPWR sky130_fd_sc_hd__decap_3
XTAP_TAPCELL_ROW_25_507 VGND VPWR sky130_fd_sc_hd__tapvpwrvgnd_1
XTAP_TAPCELL_ROW_53_816 VGND VPWR sky130_fd_sc_hd__tapvpwrvgnd_1
XTAP_TAPCELL_ROW_81_1126 VGND VPWR sky130_fd_sc_hd__tapvpwrvgnd_1
XFILLER_23_556 VGND VGND VPWR VPWR sky130_fd_sc_hd__decap_4
XFILLER_24_27 VGND VGND VPWR VPWR sky130_fd_sc_hd__fill_1
XPHY_EDGE_ROW_59_Left_166 VGND VGND VPWR VPWR sky130_fd_sc_hd__decap_3
X_3978_ lsu.load_fifo.queue\[12\]\[3\] lsu.load_fifo.queue\[13\]\[3\] lsu.load_fifo.queue\[14\]\[3\]
+ lsu.load_fifo.queue\[15\]\[3\] net383 net366 VGND VGND VPWR VPWR _1422_ sky130_fd_sc_hd__mux4_1
X_2929_ net933 net306 net221 VGND VGND VPWR VPWR _0441_ sky130_fd_sc_hd__mux2_1
XTAP_TAPCELL_ROW_33_595 VGND VPWR sky130_fd_sc_hd__tapvpwrvgnd_1
XTAP_TAPCELL_ROW_79_1099 VGND VPWR sky130_fd_sc_hd__tapvpwrvgnd_1
Xhold251 net111 VGND VGND VPWR VPWR net719 sky130_fd_sc_hd__dlygate4sd3_1
XTAP_TAPCELL_ROW_92_1244 VGND VPWR sky130_fd_sc_hd__tapvpwrvgnd_1
XPHY_EDGE_ROW_68_Left_175 VGND VGND VPWR VPWR sky130_fd_sc_hd__decap_3
Xhold240 lsu.load_fifo.queue\[0\]\[3\] VGND VGND VPWR VPWR net708 sky130_fd_sc_hd__dlygate4sd3_1
Xhold262 lsu.store_fifo.queue\[7\]\[0\] VGND VGND VPWR VPWR net730 sky130_fd_sc_hd__dlygate4sd3_1
Xhold284 lsu.load_fifo.queue\[5\]\[2\] VGND VGND VPWR VPWR net752 sky130_fd_sc_hd__dlygate4sd3_1
Xhold273 lsu.load_fifo.queue\[2\]\[17\] VGND VGND VPWR VPWR net741 sky130_fd_sc_hd__dlygate4sd3_1
Xhold295 lsu.load_fifo.queue\[4\]\[15\] VGND VGND VPWR VPWR net763 sky130_fd_sc_hd__dlygate4sd3_1
XFILLER_105_30 VPWR VGND VPWR VGND sky130_ef_sc_hd__decap_12
XFILLER_92_209 VPWR VGND VPWR VGND sky130_ef_sc_hd__decap_12
XTAP_TAPCELL_ROW_5_287 VGND VPWR sky130_fd_sc_hd__tapvpwrvgnd_1
XFILLER_58_464 VGND VGND VPWR VPWR sky130_fd_sc_hd__fill_1
XFILLER_73_412 VPWR VGND VPWR VGND sky130_ef_sc_hd__decap_12
XTAP_TAPCELL_ROW_69_993 VGND VPWR sky130_fd_sc_hd__tapvpwrvgnd_1
XFILLER_58_486 VGND VGND VPWR VPWR sky130_fd_sc_hd__decap_3
XFILLER_45_169 VGND VGND VPWR VPWR sky130_fd_sc_hd__decap_8
XPHY_EDGE_ROW_77_Left_184 VGND VGND VPWR VPWR sky130_fd_sc_hd__decap_3
XFILLER_14_501 VPWR VGND VPWR VGND sky130_ef_sc_hd__decap_12
XFILLER_26_350 VGND VGND VPWR VPWR sky130_fd_sc_hd__decap_6
XFILLER_14_545 VPWR VGND VPWR VGND sky130_ef_sc_hd__decap_12
XFILLER_26_394 VGND VGND VPWR VPWR sky130_fd_sc_hd__decap_3
XFILLER_53_191 VGND VGND VPWR VPWR sky130_fd_sc_hd__decap_3
XTAP_TAPCELL_ROW_101_1340 VGND VPWR sky130_fd_sc_hd__tapvpwrvgnd_1
XFILLER_14_589 VPWR VGND VPWR VGND sky130_ef_sc_hd__decap_12
XFILLER_14_60 VGND VGND VPWR VPWR sky130_fd_sc_hd__fill_1
XFILLER_5_221 VGND VGND VPWR VPWR sky130_fd_sc_hd__decap_3
XPHY_EDGE_ROW_86_Left_193 VGND VGND VPWR VPWR sky130_fd_sc_hd__decap_3
Xinput8 count[15] VGND VGND VPWR VPWR net8 sky130_fd_sc_hd__buf_2
XFILLER_76_261 VGND VGND VPWR VPWR sky130_fd_sc_hd__decap_3
XFILLER_24_309 VGND VGND VPWR VPWR sky130_fd_sc_hd__decap_4
X_4950_ clknet_leaf_7_clk _1005_ _0136_ VGND VGND VPWR VPWR acc.byte0\[3\] sky130_fd_sc_hd__dfrtp_1
XFILLER_52_629 VGND VGND VPWR VPWR sky130_fd_sc_hd__fill_1
XFILLER_17_383 VGND VGND VPWR VPWR sky130_fd_sc_hd__decap_8
X_3901_ lsu.load_fifo.queue\[8\]\[14\] lsu.load_fifo.queue\[9\]\[14\] lsu.load_fifo.queue\[10\]\[14\]
+ lsu.load_fifo.queue\[11\]\[14\] net385 net368 VGND VGND VPWR VPWR _1356_ sky130_fd_sc_hd__mux4_1
X_4881_ clknet_leaf_34_clk _0936_ VGND VGND VPWR VPWR lsu.load_fifo.queue\[12\]\[8\]
+ sky130_fd_sc_hd__dfxtp_1
X_3832_ lsu.load_fifo.queue\[12\]\[24\] lsu.load_fifo.queue\[13\]\[24\] lsu.load_fifo.queue\[14\]\[24\]
+ lsu.load_fifo.queue\[15\]\[24\] net397 net379 VGND VGND VPWR VPWR _1297_ sky130_fd_sc_hd__mux4_1
X_3763_ net282 _1126_ _1239_ VGND VGND VPWR VPWR _1080_ sky130_fd_sc_hd__a21o_1
XTAP_TAPCELL_ROW_30_565 VGND VPWR sky130_fd_sc_hd__tapvpwrvgnd_1
X_3694_ _1135_ _1152_ VGND VGND VPWR VPWR _1176_ sky130_fd_sc_hd__xnor2_1
X_2714_ net275 net1131 _2023_ VGND VGND VPWR VPWR _0237_ sky130_fd_sc_hd__mux2_1
X_2645_ lsu.store_fifo.w_ptr\[0\] _2011_ VGND VGND VPWR VPWR _2018_ sky130_fd_sc_hd__or2_1
X_2576_ lsu.current_load_addr\[9\] _1969_ net162 VGND VGND VPWR VPWR _0736_ sky130_fd_sc_hd__mux2_4
X_4315_ clknet_leaf_27_clk _0372_ VGND VGND VPWR VPWR lsu.load_fifo.queue\[10\]\[21\]
+ sky130_fd_sc_hd__dfxtp_1
X_4246_ clknet_leaf_57_clk _0303_ VGND VGND VPWR VPWR lsu.store_fifo.queue\[2\]\[4\]
+ sky130_fd_sc_hd__dfxtp_1
X_4177_ clknet_leaf_65_clk _0234_ VGND VGND VPWR VPWR lsu.store_fifo.queue\[9\]\[5\]
+ sky130_fd_sc_hd__dfxtp_1
XFILLER_95_581 VPWR VGND VPWR VGND sky130_ef_sc_hd__decap_12
X_3128_ net860 net311 net182 VGND VGND VPWR VPWR _0631_ sky130_fd_sc_hd__mux2_1
XFILLER_82_242 VGND VGND VPWR VPWR sky130_fd_sc_hd__fill_2
XTAP_TAPCELL_ROW_2_257 VGND VPWR sky130_fd_sc_hd__tapvpwrvgnd_1
XTAP_TAPCELL_ROW_38_643 VGND VPWR sky130_fd_sc_hd__tapvpwrvgnd_1
XTAP_TAPCELL_ROW_66_952 VGND VPWR sky130_fd_sc_hd__tapvpwrvgnd_1
XFILLER_27_169 VGND VGND VPWR VPWR sky130_fd_sc_hd__decap_8
X_3059_ net964 net316 net206 VGND VGND VPWR VPWR _0564_ sky130_fd_sc_hd__mux2_1
XFILLER_43_629 VGND VGND VPWR VPWR sky130_fd_sc_hd__fill_1
XFILLER_50_194 VGND VGND VPWR VPWR sky130_fd_sc_hd__fill_2
XFILLER_11_559 VGND VGND VPWR VPWR sky130_fd_sc_hd__fill_1
XFILLER_78_537 VGND VGND VPWR VPWR sky130_fd_sc_hd__fill_1
XFILLER_18_147 VGND VGND VPWR VPWR sky130_fd_sc_hd__fill_1
XFILLER_34_607 VGND VGND VPWR VPWR sky130_fd_sc_hd__fill_1
XFILLER_61_415 VGND VGND VPWR VPWR sky130_fd_sc_hd__fill_2
XFILLER_92_65 VPWR VGND VPWR VGND sky130_ef_sc_hd__decap_12
XFILLER_14_386 VPWR VGND VPWR VGND sky130_ef_sc_hd__decap_12
XPHY_EDGE_ROW_94_Left_201 VGND VGND VPWR VPWR sky130_fd_sc_hd__decap_3
XFILLER_10_581 VGND VGND VPWR VPWR sky130_fd_sc_hd__decap_6
X_2430_ lsu.current_store_addr\[19\] _1863_ net242 VGND VGND VPWR VPWR _0808_ sky130_fd_sc_hd__mux2_1
XFILLER_51_6 VGND VGND VPWR VPWR sky130_fd_sc_hd__fill_2
XFILLER_96_301 VGND VGND VPWR VPWR sky130_fd_sc_hd__decap_6
X_2361_ lsu.store_counter\[11\] _1601_ _1612_ lsu.store_counter\[8\] _1799_ VGND VGND
+ VPWR VPWR _1800_ sky130_fd_sc_hd__a221o_1
X_2292_ net266 _1731_ net239 VGND VGND VPWR VPWR _1749_ sky130_fd_sc_hd__o21ai_1
XFILLER_69_559 VGND VGND VPWR VPWR sky130_fd_sc_hd__fill_1
XFILLER_69_537 VGND VGND VPWR VPWR sky130_fd_sc_hd__decap_3
X_4100_ lsu.store_fifo.queue\[4\]\[1\] lsu.store_fifo.queue\[5\]\[1\] lsu.store_fifo.queue\[6\]\[1\]
+ lsu.store_fifo.queue\[7\]\[1\] net411 net406 VGND VGND VPWR VPWR _1532_ sky130_fd_sc_hd__mux4_1
XFILLER_84_529 VGND VGND VPWR VPWR sky130_fd_sc_hd__decap_3
XFILLER_2_41 VPWR VGND VPWR VGND sky130_ef_sc_hd__decap_12
X_4031_ net400 _1468_ VGND VGND VPWR VPWR _1469_ sky130_fd_sc_hd__nor2_1
XFILLER_2_85 VGND VGND VPWR VPWR sky130_fd_sc_hd__decap_6
XFILLER_64_231 VGND VGND VPWR VPWR sky130_fd_sc_hd__fill_2
XFILLER_25_629 VGND VGND VPWR VPWR sky130_fd_sc_hd__fill_1
XTAP_TAPCELL_ROW_35_613 VGND VPWR sky130_fd_sc_hd__tapvpwrvgnd_1
XTAP_TAPCELL_ROW_63_922 VGND VPWR sky130_fd_sc_hd__tapvpwrvgnd_1
XFILLER_24_139 VGND VGND VPWR VPWR sky130_fd_sc_hd__fill_1
X_4933_ clknet_leaf_16_clk _0988_ VGND VGND VPWR VPWR lsu.load_fifo.queue\[13\]\[28\]
+ sky130_fd_sc_hd__dfxtp_1
X_4864_ clknet_leaf_42_clk _0919_ _0114_ VGND VGND VPWR VPWR lsu.load_counter\[14\]
+ sky130_fd_sc_hd__dfrtp_2
XTAP_TAPCELL_ROW_15_392 VGND VPWR sky130_fd_sc_hd__tapvpwrvgnd_1
X_3815_ net1262 _1282_ net255 VGND VGND VPWR VPWR _1029_ sky130_fd_sc_hd__mux2_1
X_4795_ clknet_leaf_5_clk _0852_ VGND VGND VPWR VPWR lsu.load_fifo.data_in\[5\] sky130_fd_sc_hd__dfxtp_1
X_3746_ _1188_ _1227_ _1187_ VGND VGND VPWR VPWR _1228_ sky130_fd_sc_hd__a21o_1
XFILLER_9_390 VGND VGND VPWR VPWR sky130_fd_sc_hd__fill_2
X_3677_ _1129_ _1154_ VGND VGND VPWR VPWR _1159_ sky130_fd_sc_hd__xnor2_1
Xoutput120 net120 VGND VGND VPWR VPWR load_addr[4] sky130_fd_sc_hd__buf_2
X_2628_ lsu.load_fifo.w_ptr\[0\] _1996_ VGND VGND VPWR VPWR _2005_ sky130_fd_sc_hd__or2_1
XTAP_TAPCELL_ROW_76_1069 VGND VPWR sky130_fd_sc_hd__tapvpwrvgnd_1
Xoutput131 net131 VGND VGND VPWR VPWR store_addr[13] sky130_fd_sc_hd__buf_2
XTAP_TAPCELL_ROW_7_305 VGND VPWR sky130_fd_sc_hd__tapvpwrvgnd_1
Xoutput142 net142 VGND VGND VPWR VPWR store_addr[3] sky130_fd_sc_hd__buf_2
XFILLER_102_601 VPWR VGND VPWR VGND sky130_ef_sc_hd__decap_12
X_2559_ net28 net259 _1955_ _1956_ VGND VGND VPWR VPWR _1957_ sky130_fd_sc_hd__a22o_1
XFILLER_99_161 VGND VGND VPWR VPWR sky130_fd_sc_hd__fill_1
Xoutput153 net153 VGND VGND VPWR VPWR store_data[4] sky130_fd_sc_hd__buf_2
X_4229_ clknet_leaf_58_clk _0286_ VGND VGND VPWR VPWR lsu.store_fifo.queue\[4\]\[7\]
+ sky130_fd_sc_hd__dfxtp_1
XFILLER_55_242 VGND VGND VPWR VPWR sky130_fd_sc_hd__decap_8
XFILLER_16_629 VGND VGND VPWR VPWR sky130_fd_sc_hd__fill_1
XFILLER_46_69 VGND VGND VPWR VPWR sky130_fd_sc_hd__decap_6
XFILLER_102_53 VPWR VGND VPWR VGND sky130_ef_sc_hd__decap_12
XTAP_TAPCELL_ROW_87_1187 VGND VPWR sky130_fd_sc_hd__tapvpwrvgnd_1
XFILLER_7_19 VGND VGND VPWR VPWR sky130_fd_sc_hd__fill_1
XFILLER_11_50 VGND VGND VPWR VPWR sky130_fd_sc_hd__decap_6
XFILLER_11_72 VGND VGND VPWR VPWR sky130_fd_sc_hd__decap_3
XFILLER_87_76 VGND VGND VPWR VPWR sky130_fd_sc_hd__fill_1
XFILLER_87_65 VGND VGND VPWR VPWR sky130_fd_sc_hd__fill_2
XFILLER_93_337 VPWR VGND VPWR VGND sky130_ef_sc_hd__decap_12
Xfanout380 net381 VGND VGND VPWR VPWR net380 sky130_fd_sc_hd__buf_2
XFILLER_19_401 VPWR VGND VPWR VGND sky130_ef_sc_hd__decap_12
Xfanout391 net392 VGND VGND VPWR VPWR net391 sky130_fd_sc_hd__buf_4
XFILLER_19_445 VGND VGND VPWR VPWR sky130_fd_sc_hd__decap_3
XFILLER_46_231 VGND VGND VPWR VPWR sky130_fd_sc_hd__decap_6
XFILLER_34_415 VGND VGND VPWR VPWR sky130_fd_sc_hd__decap_4
XFILLER_46_253 VPWR VGND VPWR VGND sky130_ef_sc_hd__decap_12
XFILLER_99_6 VPWR VGND VPWR VGND sky130_ef_sc_hd__decap_12
Xinput11 count[18] VGND VGND VPWR VPWR net11 sky130_fd_sc_hd__dlymetal6s2s_1
Xinput22 count[8] VGND VGND VPWR VPWR net22 sky130_fd_sc_hd__clkbuf_1
X_4580_ clknet_leaf_14_clk _0637_ VGND VGND VPWR VPWR lsu.load_fifo.queue\[0\]\[28\]
+ sky130_fd_sc_hd__dfxtp_1
XTAP_TAPCELL_ROW_12_362 VGND VPWR sky130_fd_sc_hd__tapvpwrvgnd_1
X_3600_ net424 VGND VGND VPWR VPWR _0164_ sky130_fd_sc_hd__inv_2
XTAP_TAPCELL_ROW_40_671 VGND VPWR sky130_fd_sc_hd__tapvpwrvgnd_1
Xinput44 load_base_addr[8] VGND VGND VPWR VPWR net44 sky130_fd_sc_hd__clkbuf_1
Xinput33 load_base_addr[18] VGND VGND VPWR VPWR net33 sky130_fd_sc_hd__clkbuf_1
X_3531_ net442 VGND VGND VPWR VPWR _0095_ sky130_fd_sc_hd__inv_2
Xinput55 load_data[17] VGND VGND VPWR VPWR net55 sky130_fd_sc_hd__clkbuf_1
Xinput77 load_data[8] VGND VGND VPWR VPWR net77 sky130_fd_sc_hd__clkbuf_1
Xinput88 store_base_addr[17] VGND VGND VPWR VPWR net88 sky130_fd_sc_hd__buf_1
Xhold817 lsu.current_store_addr\[12\] VGND VGND VPWR VPWR net1285 sky130_fd_sc_hd__dlygate4sd3_1
Xinput66 load_data[27] VGND VGND VPWR VPWR net66 sky130_fd_sc_hd__clkbuf_1
Xhold806 acc.byte2\[1\] VGND VGND VPWR VPWR net1274 sky130_fd_sc_hd__dlygate4sd3_1
Xhold828 lsu.current_store_addr\[14\] VGND VGND VPWR VPWR net1296 sky130_fd_sc_hd__dlygate4sd3_1
X_3462_ net426 VGND VGND VPWR VPWR _0026_ sky130_fd_sc_hd__inv_2
Xhold839 lsu.current_store_addr\[3\] VGND VGND VPWR VPWR net1307 sky130_fd_sc_hd__dlygate4sd3_1
XFILLER_6_382 VPWR VGND VPWR VGND sky130_ef_sc_hd__decap_12
Xinput99 store_base_addr[7] VGND VGND VPWR VPWR net99 sky130_fd_sc_hd__clkbuf_1
XFILLER_88_109 VPWR VGND VPWR VGND sky130_ef_sc_hd__decap_12
X_3393_ net698 net337 net199 VGND VGND VPWR VPWR _1043_ sky130_fd_sc_hd__mux2_1
X_2413_ lsu.current_store_addr\[11\] lsu.current_store_addr\[10\] lsu.current_store_addr\[9\]
+ _1847_ VGND VGND VPWR VPWR _1849_ sky130_fd_sc_hd__and4_1
X_2344_ lsu.store_counter\[18\] _1574_ _1578_ lsu.store_counter\[17\] VGND VGND VPWR
+ VPWR _1783_ sky130_fd_sc_hd__a2bb2o_1
XFILLER_96_153 VPWR VGND VPWR VGND sky130_ef_sc_hd__decap_12
XFILLER_69_367 VPWR VGND VPWR VGND sky130_ef_sc_hd__decap_12
XFILLER_96_197 VPWR VGND VPWR VGND sky130_ef_sc_hd__decap_12
X_2275_ net241 _1735_ lsu.store_counter\[21\] VGND VGND VPWR VPWR _1739_ sky130_fd_sc_hd__a21o_1
XFILLER_84_359 VGND VGND VPWR VPWR sky130_fd_sc_hd__decap_4
X_4014_ net270 _1453_ VGND VGND VPWR VPWR _1454_ sky130_fd_sc_hd__nor2_1
XFILLER_37_220 VGND VGND VPWR VPWR sky130_fd_sc_hd__decap_4
XTAP_TAPCELL_ROW_48_760 VGND VPWR sky130_fd_sc_hd__tapvpwrvgnd_1
XFILLER_80_598 VGND VGND VPWR VPWR sky130_fd_sc_hd__decap_4
X_4916_ clknet_leaf_84_clk _0971_ VGND VGND VPWR VPWR lsu.load_fifo.queue\[13\]\[11\]
+ sky130_fd_sc_hd__dfxtp_1
X_4847_ clknet_leaf_35_clk _0903_ _0097_ VGND VGND VPWR VPWR lsu.acc_state\[0\] sky130_fd_sc_hd__dfrtp_1
XFILLER_32_27 VGND VGND VPWR VPWR sky130_fd_sc_hd__fill_1
XFILLER_32_38 VGND VGND VPWR VPWR sky130_fd_sc_hd__fill_1
X_4778_ clknet_leaf_44_clk _0835_ _0070_ VGND VGND VPWR VPWR net103 sky130_fd_sc_hd__dfrtp_1
XFILLER_20_197 VGND VGND VPWR VPWR sky130_fd_sc_hd__decap_6
X_3729_ _1208_ _1209_ _1207_ VGND VGND VPWR VPWR _1211_ sky130_fd_sc_hd__a21boi_1
XFILLER_106_225 VGND VGND VPWR VPWR sky130_fd_sc_hd__decap_4
XFILLER_102_475 VGND VGND VPWR VPWR sky130_fd_sc_hd__fill_1
XTAP_TAPCELL_ROW_89_1205 VGND VPWR sky130_fd_sc_hd__tapvpwrvgnd_1
XFILLER_90_307 VGND VGND VPWR VPWR sky130_fd_sc_hd__fill_1
XFILLER_28_253 VGND VGND VPWR VPWR sky130_fd_sc_hd__decap_4
XFILLER_43_245 VGND VGND VPWR VPWR sky130_fd_sc_hd__decap_3
XFILLER_8_625 VGND VGND VPWR VPWR sky130_fd_sc_hd__decap_4
XFILLER_7_113 VGND VGND VPWR VPWR sky130_fd_sc_hd__fill_1
XFILLER_11_186 VGND VGND VPWR VPWR sky130_fd_sc_hd__decap_4
XFILLER_98_53 VPWR VGND VPWR VGND sky130_ef_sc_hd__decap_12
XFILLER_98_97 VPWR VGND VPWR VGND sky130_ef_sc_hd__decap_12
X_2060_ _1549_ VGND VGND VPWR VPWR _1550_ sky130_fd_sc_hd__inv_2
XFILLER_93_167 VGND VGND VPWR VPWR sky130_fd_sc_hd__fill_1
XFILLER_74_381 VPWR VGND VPWR VGND sky130_ef_sc_hd__decap_12
XTAP_TAPCELL_ROW_17_421 VGND VPWR sky130_fd_sc_hd__tapvpwrvgnd_1
XTAP_TAPCELL_ROW_45_730 VGND VPWR sky130_fd_sc_hd__tapvpwrvgnd_1
XFILLER_34_256 VGND VGND VPWR VPWR sky130_fd_sc_hd__decap_4
XFILLER_97_3 VPWR VGND VPWR VGND sky130_ef_sc_hd__decap_12
X_2962_ net306 net1224 net217 VGND VGND VPWR VPWR _0473_ sky130_fd_sc_hd__mux2_1
XPHY_EDGE_ROW_22_Left_129 VGND VGND VPWR VPWR sky130_fd_sc_hd__decap_3
X_4701_ clknet_leaf_59_clk _0758_ VGND VGND VPWR VPWR lsu.store_fifo.queue\[14\]\[5\]
+ sky130_fd_sc_hd__dfxtp_1
X_4632_ clknet_leaf_31_clk _0689_ VGND VGND VPWR VPWR lsu.load_fifo.queue\[15\]\[16\]
+ sky130_fd_sc_hd__dfxtp_1
X_2893_ net551 net312 net195 VGND VGND VPWR VPWR _0404_ sky130_fd_sc_hd__mux2_1
Xhold603 lsu.load_fifo.queue\[3\]\[25\] VGND VGND VPWR VPWR net1071 sky130_fd_sc_hd__dlygate4sd3_1
X_4563_ clknet_leaf_85_clk _0620_ VGND VGND VPWR VPWR lsu.load_fifo.queue\[0\]\[11\]
+ sky130_fd_sc_hd__dfxtp_1
Xhold636 lsu.load_fifo.queue\[1\]\[10\] VGND VGND VPWR VPWR net1104 sky130_fd_sc_hd__dlygate4sd3_1
Xhold614 lsu.load_fifo.queue\[1\]\[7\] VGND VGND VPWR VPWR net1082 sky130_fd_sc_hd__dlygate4sd3_1
X_3514_ net436 VGND VGND VPWR VPWR _0078_ sky130_fd_sc_hd__inv_2
X_4494_ clknet_leaf_87_clk _0551_ VGND VGND VPWR VPWR lsu.load_fifo.queue\[2\]\[6\]
+ sky130_fd_sc_hd__dfxtp_1
Xhold625 lsu.load_fifo.queue\[4\]\[30\] VGND VGND VPWR VPWR net1093 sky130_fd_sc_hd__dlygate4sd3_1
X_3445_ net435 VGND VGND VPWR VPWR _0009_ sky130_fd_sc_hd__inv_2
Xhold647 lsu.load_fifo.queue\[15\]\[21\] VGND VGND VPWR VPWR net1115 sky130_fd_sc_hd__dlygate4sd3_1
XTAP_TAPCELL_ROW_73_1028 VGND VPWR sky130_fd_sc_hd__tapvpwrvgnd_1
Xhold669 lsu.load_fifo.queue\[5\]\[20\] VGND VGND VPWR VPWR net1137 sky130_fd_sc_hd__dlygate4sd3_1
XPHY_EDGE_ROW_31_Left_138 VGND VGND VPWR VPWR sky130_fd_sc_hd__decap_3
Xhold658 lsu.load_fifo.queue\[9\]\[28\] VGND VGND VPWR VPWR net1126 sky130_fd_sc_hd__dlygate4sd3_1
X_3376_ net304 net1206 net170 VGND VGND VPWR VPWR _0985_ sky130_fd_sc_hd__mux2_1
X_2327_ lsu.store_counter\[0\] _1720_ _1769_ VGND VGND VPWR VPWR _0880_ sky130_fd_sc_hd__o21ba_1
XFILLER_84_101 VGND VGND VPWR VPWR sky130_fd_sc_hd__decap_6
X_2258_ net79 _1716_ _1722_ VGND VGND VPWR VPWR _1723_ sky130_fd_sc_hd__o21ba_1
XFILLER_57_337 VPWR VGND VPWR VGND sky130_ef_sc_hd__decap_12
X_2189_ net480 net166 net264 net243 VGND VGND VPWR VPWR _1679_ sky130_fd_sc_hd__o211a_4
XFILLER_53_521 VGND VGND VPWR VPWR sky130_fd_sc_hd__decap_4
XTAP_TAPCELL_ROW_84_1157 VGND VPWR sky130_fd_sc_hd__tapvpwrvgnd_1
XPHY_EDGE_ROW_40_Left_147 VGND VGND VPWR VPWR sky130_fd_sc_hd__decap_3
XFILLER_80_395 VGND VGND VPWR VPWR sky130_fd_sc_hd__decap_8
XFILLER_13_429 VPWR VGND VPWR VGND sky130_ef_sc_hd__decap_12
XTAP_TAPCELL_ROW_23_479 VGND VPWR sky130_fd_sc_hd__tapvpwrvgnd_1
XTAP_TAPCELL_ROW_51_788 VGND VPWR sky130_fd_sc_hd__tapvpwrvgnd_1
XFILLER_5_617 VPWR VGND VPWR VGND sky130_ef_sc_hd__decap_12
XTAP_TAPCELL_ROW_95_1275 VGND VPWR sky130_fd_sc_hd__tapvpwrvgnd_1
XFILLER_0_300 VGND VGND VPWR VPWR sky130_fd_sc_hd__decap_8
XFILLER_0_377 VPWR VGND VPWR VGND sky130_ef_sc_hd__decap_12
XTAP_TAPCELL_ROW_59_877 VGND VPWR sky130_fd_sc_hd__tapvpwrvgnd_1
XFILLER_84_66 VGND VGND VPWR VPWR sky130_fd_sc_hd__fill_2
XTAP_TAPCELL_ROW_104_1371 VGND VPWR sky130_fd_sc_hd__tapvpwrvgnd_1
XFILLER_8_433 VPWR VGND VPWR VGND sky130_ef_sc_hd__decap_12
XFILLER_8_477 VPWR VGND VPWR VGND sky130_ef_sc_hd__decap_12
X_3230_ net616 lsu.current_load_addr\[2\] net237 VGND VGND VPWR VPWR _0768_ sky130_fd_sc_hd__mux2_1
XFILLER_3_182 VGND VGND VPWR VPWR sky130_fd_sc_hd__fill_1
X_3161_ net706 net311 net178 VGND VGND VPWR VPWR _0663_ sky130_fd_sc_hd__mux2_1
X_2112_ _1561_ _1600_ lsu.load_counter\[11\] VGND VGND VPWR VPWR _1602_ sky130_fd_sc_hd__a21oi_1
XFILLER_94_421 VGND VGND VPWR VPWR sky130_fd_sc_hd__decap_8
XFILLER_12_3 VGND VGND VPWR VPWR sky130_fd_sc_hd__decap_8
XFILLER_39_337 VGND VGND VPWR VPWR sky130_fd_sc_hd__decap_3
X_3092_ net316 net1144 net185 VGND VGND VPWR VPWR _0596_ sky130_fd_sc_hd__mux2_1
X_3994_ lsu.load_fifo.queue\[4\]\[0\] lsu.load_fifo.queue\[5\]\[0\] lsu.load_fifo.queue\[6\]\[0\]
+ lsu.load_fifo.queue\[7\]\[0\] net397 net380 VGND VGND VPWR VPWR _1435_ sky130_fd_sc_hd__mux4_1
X_2945_ net341 net1152 net217 VGND VGND VPWR VPWR _0456_ sky130_fd_sc_hd__mux2_1
X_2876_ net1018 net346 net195 VGND VGND VPWR VPWR _0387_ sky130_fd_sc_hd__mux2_1
XTAP_TAPCELL_ROW_20_449 VGND VPWR sky130_fd_sc_hd__tapvpwrvgnd_1
X_4615_ clknet_leaf_75_clk _0672_ VGND VGND VPWR VPWR lsu.load_fifo.queue\[8\]\[31\]
+ sky130_fd_sc_hd__dfxtp_1
Xhold400 lsu.store_fifo.queue\[2\]\[3\] VGND VGND VPWR VPWR net868 sky130_fd_sc_hd__dlygate4sd3_1
Xhold411 lsu.load_fifo.queue\[14\]\[31\] VGND VGND VPWR VPWR net879 sky130_fd_sc_hd__dlygate4sd3_1
X_4546_ clknet_leaf_10_clk _0603_ VGND VGND VPWR VPWR lsu.load_fifo.queue\[1\]\[26\]
+ sky130_fd_sc_hd__dfxtp_1
Xhold433 lsu.load_fifo.queue\[7\]\[23\] VGND VGND VPWR VPWR net901 sky130_fd_sc_hd__dlygate4sd3_1
Xhold422 lsu.store_fifo.queue\[6\]\[1\] VGND VGND VPWR VPWR net890 sky130_fd_sc_hd__dlygate4sd3_1
Xhold444 lsu.load_fifo.queue\[0\]\[30\] VGND VGND VPWR VPWR net912 sky130_fd_sc_hd__dlygate4sd3_1
Xhold455 _0829_ VGND VGND VPWR VPWR net923 sky130_fd_sc_hd__dlygate4sd3_1
XFILLER_89_237 VPWR VGND VPWR VGND sky130_ef_sc_hd__decap_12
Xhold477 lsu.load_fifo.queue\[6\]\[16\] VGND VGND VPWR VPWR net945 sky130_fd_sc_hd__dlygate4sd3_1
X_4477_ clknet_leaf_14_clk _0534_ VGND VGND VPWR VPWR lsu.load_fifo.queue\[3\]\[21\]
+ sky130_fd_sc_hd__dfxtp_1
Xhold466 lsu.load_fifo.queue\[15\]\[0\] VGND VGND VPWR VPWR net934 sky130_fd_sc_hd__dlygate4sd3_1
Xhold499 lsu.load_fifo.queue\[9\]\[24\] VGND VGND VPWR VPWR net967 sky130_fd_sc_hd__dlygate4sd3_1
Xhold488 lsu.load_fifo.queue\[0\]\[15\] VGND VGND VPWR VPWR net956 sky130_fd_sc_hd__dlygate4sd3_1
X_3428_ net560 net291 _2059_ VGND VGND VPWR VPWR _1086_ sky130_fd_sc_hd__mux2_1
X_3359_ net338 net1113 net172 VGND VGND VPWR VPWR _0968_ sky130_fd_sc_hd__mux2_1
XFILLER_97_281 VPWR VGND VPWR VGND sky130_ef_sc_hd__decap_12
XFILLER_26_510 VPWR VGND VPWR VGND sky130_ef_sc_hd__decap_12
XTAP_TAPCELL_ROW_28_538 VGND VPWR sky130_fd_sc_hd__tapvpwrvgnd_1
X_5029_ clknet_leaf_55_clk _1084_ _0173_ VGND VGND VPWR VPWR acc.data_out\[8\] sky130_fd_sc_hd__dfrtp_1
XTAP_TAPCELL_ROW_56_847 VGND VPWR sky130_fd_sc_hd__tapvpwrvgnd_1
XFILLER_21_281 VGND VGND VPWR VPWR sky130_fd_sc_hd__decap_3
XFILLER_5_447 VGND VGND VPWR VPWR sky130_fd_sc_hd__fill_1
XFILLER_0_141 VGND VGND VPWR VPWR sky130_fd_sc_hd__fill_2
XFILLER_48_134 VGND VGND VPWR VPWR sky130_fd_sc_hd__fill_1
XTAP_TAPCELL_ROW_106_1411 VGND VPWR sky130_fd_sc_hd__tapvpwrvgnd_1
XTAP_TAPCELL_ROW_106_1400 VGND VPWR sky130_fd_sc_hd__tapvpwrvgnd_1
XFILLER_32_513 VGND VGND VPWR VPWR sky130_fd_sc_hd__fill_1
X_2730_ net286 net1229 net234 VGND VGND VPWR VPWR _0251_ sky130_fd_sc_hd__mux2_1
XFILLER_12_292 VGND VGND VPWR VPWR sky130_fd_sc_hd__decap_4
X_2661_ _2016_ _2020_ VGND VGND VPWR VPWR _2021_ sky130_fd_sc_hd__nor2_4
X_4400_ clknet_leaf_34_clk _0457_ VGND VGND VPWR VPWR lsu.load_fifo.queue\[5\]\[8\]
+ sky130_fd_sc_hd__dfxtp_1
X_2592_ net40 net260 VGND VGND VPWR VPWR _1981_ sky130_fd_sc_hd__and2_1
XFILLER_99_502 VGND VGND VPWR VPWR sky130_fd_sc_hd__fill_2
XFILLER_5_52 VGND VGND VPWR VPWR sky130_fd_sc_hd__decap_4
X_4331_ clknet_leaf_4_clk _0388_ VGND VGND VPWR VPWR lsu.load_fifo.queue\[7\]\[5\]
+ sky130_fd_sc_hd__dfxtp_1
Xfanout209 _2043_ VGND VGND VPWR VPWR net209 sky130_fd_sc_hd__buf_2
X_4262_ clknet_leaf_35_clk _0319_ VGND VGND VPWR VPWR lsu.load_fifo.queue\[9\]\[0\]
+ sky130_fd_sc_hd__dfxtp_1
XPHY_EDGE_ROW_105_Left_212 VGND VGND VPWR VPWR sky130_fd_sc_hd__decap_3
XFILLER_86_229 VPWR VGND VPWR VGND sky130_ef_sc_hd__decap_12
X_3213_ net276 net668 _2049_ VGND VGND VPWR VPWR _0724_ sky130_fd_sc_hd__mux2_1
XFILLER_79_281 VGND VGND VPWR VPWR sky130_fd_sc_hd__fill_2
X_4193_ clknet_leaf_70_clk _0250_ VGND VGND VPWR VPWR lsu.store_fifo.queue\[7\]\[1\]
+ sky130_fd_sc_hd__dfxtp_1
XFILLER_94_251 VGND VGND VPWR VPWR sky130_fd_sc_hd__fill_1
XFILLER_39_156 VGND VGND VPWR VPWR sky130_fd_sc_hd__decap_3
X_3144_ net769 net345 net177 VGND VGND VPWR VPWR _0646_ sky130_fd_sc_hd__mux2_1
X_3075_ net351 net1044 net187 VGND VGND VPWR VPWR _0579_ sky130_fd_sc_hd__mux2_1
XFILLER_23_502 VGND VGND VPWR VPWR sky130_fd_sc_hd__fill_2
XTAP_TAPCELL_ROW_25_508 VGND VPWR sky130_fd_sc_hd__tapvpwrvgnd_1
XTAP_TAPCELL_ROW_53_817 VGND VPWR sky130_fd_sc_hd__tapvpwrvgnd_1
XTAP_TAPCELL_ROW_81_1116 VGND VPWR sky130_fd_sc_hd__tapvpwrvgnd_1
X_3977_ lsu.load_fifo.queue\[0\]\[3\] lsu.load_fifo.queue\[1\]\[3\] lsu.load_fifo.queue\[2\]\[3\]
+ lsu.load_fifo.queue\[3\]\[3\] net383 net366 VGND VGND VPWR VPWR _1421_ sky130_fd_sc_hd__mux4_1
X_2928_ net583 net309 net219 VGND VGND VPWR VPWR _0440_ sky130_fd_sc_hd__mux2_1
XTAP_TAPCELL_ROW_33_596 VGND VPWR sky130_fd_sc_hd__tapvpwrvgnd_1
X_2859_ net822 net316 net222 VGND VGND VPWR VPWR _0370_ sky130_fd_sc_hd__mux2_1
XTAP_TAPCELL_ROW_92_1245 VGND VPWR sky130_fd_sc_hd__tapvpwrvgnd_1
Xhold252 lsu.load_fifo.queue\[10\]\[20\] VGND VGND VPWR VPWR net720 sky130_fd_sc_hd__dlygate4sd3_1
Xhold230 lsu.load_fifo.queue\[14\]\[9\] VGND VGND VPWR VPWR net698 sky130_fd_sc_hd__dlygate4sd3_1
X_4529_ clknet_leaf_82_clk _0586_ VGND VGND VPWR VPWR lsu.load_fifo.queue\[1\]\[9\]
+ sky130_fd_sc_hd__dfxtp_1
XFILLER_2_406 VPWR VGND VPWR VGND sky130_ef_sc_hd__decap_12
Xhold241 lsu.load_fifo.queue\[8\]\[13\] VGND VGND VPWR VPWR net709 sky130_fd_sc_hd__dlygate4sd3_1
Xhold285 net120 VGND VGND VPWR VPWR net753 sky130_fd_sc_hd__dlygate4sd3_1
Xhold274 lsu.load_fifo.queue\[12\]\[13\] VGND VGND VPWR VPWR net742 sky130_fd_sc_hd__dlygate4sd3_1
Xhold263 lsu.store_fifo.queue\[6\]\[4\] VGND VGND VPWR VPWR net731 sky130_fd_sc_hd__dlygate4sd3_1
Xhold296 lsu.load_fifo.queue\[7\]\[15\] VGND VGND VPWR VPWR net764 sky130_fd_sc_hd__dlygate4sd3_1
XFILLER_105_42 VPWR VGND VPWR VGND sky130_ef_sc_hd__decap_12
XTAP_TAPCELL_ROW_5_288 VGND VPWR sky130_fd_sc_hd__tapvpwrvgnd_1
XFILLER_18_307 VGND VGND VPWR VPWR sky130_fd_sc_hd__fill_1
XFILLER_73_424 VPWR VGND VPWR VGND sky130_ef_sc_hd__decap_12
XTAP_TAPCELL_ROW_69_994 VGND VPWR sky130_fd_sc_hd__tapvpwrvgnd_1
XFILLER_14_513 VPWR VGND VPWR VGND sky130_ef_sc_hd__decap_12
XFILLER_81_23 VGND VGND VPWR VPWR sky130_fd_sc_hd__fill_1
XFILLER_14_557 VPWR VGND VPWR VGND sky130_ef_sc_hd__decap_12
Xclkbuf_leaf_80_clk clknet_3_1__leaf_clk VGND VGND VPWR VPWR clknet_leaf_80_clk sky130_fd_sc_hd__clkbuf_8
XFILLER_41_321 VPWR VGND VPWR VGND sky130_ef_sc_hd__decap_12
XTAP_TAPCELL_ROW_101_1341 VGND VPWR sky130_fd_sc_hd__tapvpwrvgnd_1
XFILLER_14_94 VGND VGND VPWR VPWR sky130_fd_sc_hd__decap_6
XFILLER_14_83 VGND VGND VPWR VPWR sky130_fd_sc_hd__fill_1
XFILLER_5_211 VGND VGND VPWR VPWR sky130_fd_sc_hd__fill_1
XFILLER_5_233 VGND VGND VPWR VPWR sky130_fd_sc_hd__decap_4
XFILLER_1_461 VPWR VGND VPWR VGND sky130_ef_sc_hd__decap_12
XFILLER_76_251 VGND VGND VPWR VPWR sky130_fd_sc_hd__fill_1
Xinput9 count[16] VGND VGND VPWR VPWR net9 sky130_fd_sc_hd__buf_1
XFILLER_64_402 VGND VGND VPWR VPWR sky130_fd_sc_hd__fill_1
XFILLER_52_608 VGND VGND VPWR VPWR sky130_fd_sc_hd__fill_1
XFILLER_64_457 VGND VGND VPWR VPWR sky130_fd_sc_hd__fill_1
X_4880_ clknet_leaf_31_clk _0935_ VGND VGND VPWR VPWR lsu.load_fifo.queue\[12\]\[7\]
+ sky130_fd_sc_hd__dfxtp_1
X_3900_ lsu.load_fifo.queue\[12\]\[14\] lsu.load_fifo.queue\[13\]\[14\] lsu.load_fifo.queue\[14\]\[14\]
+ lsu.load_fifo.queue\[15\]\[14\] net385 net368 VGND VGND VPWR VPWR _1355_ sky130_fd_sc_hd__mux4_1
XFILLER_32_321 VGND VGND VPWR VPWR sky130_fd_sc_hd__fill_2
Xclkbuf_leaf_71_clk clknet_3_4__leaf_clk VGND VGND VPWR VPWR clknet_leaf_71_clk sky130_fd_sc_hd__clkbuf_8
XFILLER_44_192 VGND VGND VPWR VPWR sky130_fd_sc_hd__fill_1
X_3831_ lsu.load_fifo.queue\[0\]\[24\] lsu.load_fifo.queue\[1\]\[24\] lsu.load_fifo.queue\[2\]\[24\]
+ lsu.load_fifo.queue\[3\]\[24\] net397 net379 VGND VGND VPWR VPWR _1296_ sky130_fd_sc_hd__mux4_1
X_3762_ _1125_ _1226_ _1238_ VGND VGND VPWR VPWR _1239_ sky130_fd_sc_hd__and3_1
XFILLER_9_561 VPWR VGND VPWR VGND sky130_ef_sc_hd__decap_12
XTAP_TAPCELL_ROW_30_555 VGND VPWR sky130_fd_sc_hd__tapvpwrvgnd_1
X_2713_ net276 net1158 _2023_ VGND VGND VPWR VPWR _0236_ sky130_fd_sc_hd__mux2_1
X_3693_ _1173_ _1174_ VGND VGND VPWR VPWR _1175_ sky130_fd_sc_hd__nand2_1
X_2644_ net420 _2012_ VGND VGND VPWR VPWR _0706_ sky130_fd_sc_hd__xnor2_1
X_2575_ net45 net260 _1967_ _1968_ VGND VGND VPWR VPWR _1969_ sky130_fd_sc_hd__a22o_1
X_4314_ clknet_leaf_84_clk _0371_ VGND VGND VPWR VPWR lsu.load_fifo.queue\[10\]\[20\]
+ sky130_fd_sc_hd__dfxtp_1
X_4245_ clknet_leaf_70_clk _0302_ VGND VGND VPWR VPWR lsu.store_fifo.queue\[2\]\[3\]
+ sky130_fd_sc_hd__dfxtp_1
X_4176_ clknet_leaf_60_clk _0233_ VGND VGND VPWR VPWR lsu.store_fifo.queue\[9\]\[4\]
+ sky130_fd_sc_hd__dfxtp_1
XFILLER_95_593 VGND VGND VPWR VPWR sky130_fd_sc_hd__decap_8
XFILLER_95_571 VGND VGND VPWR VPWR sky130_fd_sc_hd__fill_2
X_3127_ net950 net312 net183 VGND VGND VPWR VPWR _0630_ sky130_fd_sc_hd__mux2_1
XTAP_TAPCELL_ROW_2_247 VGND VPWR sky130_fd_sc_hd__tapvpwrvgnd_1
XFILLER_55_424 VPWR VGND VPWR VGND sky130_ef_sc_hd__decap_12
XTAP_TAPCELL_ROW_38_644 VGND VPWR sky130_fd_sc_hd__tapvpwrvgnd_1
XTAP_TAPCELL_ROW_66_953 VGND VPWR sky130_fd_sc_hd__tapvpwrvgnd_1
X_3058_ net850 net319 net206 VGND VGND VPWR VPWR _0563_ sky130_fd_sc_hd__mux2_1
XFILLER_23_310 VGND VGND VPWR VPWR sky130_fd_sc_hd__fill_1
Xclkbuf_leaf_62_clk clknet_3_5__leaf_clk VGND VGND VPWR VPWR clknet_leaf_62_clk sky130_fd_sc_hd__clkbuf_8
XFILLER_63_490 VGND VGND VPWR VPWR sky130_fd_sc_hd__decap_3
XFILLER_11_505 VPWR VGND VPWR VGND sky130_ef_sc_hd__decap_12
XFILLER_19_605 VGND VGND VPWR VPWR sky130_fd_sc_hd__decap_8
XFILLER_76_78 VGND VGND VPWR VPWR sky130_fd_sc_hd__decap_6
XFILLER_73_221 VGND VGND VPWR VPWR sky130_fd_sc_hd__decap_3
XFILLER_18_137 VGND VGND VPWR VPWR sky130_fd_sc_hd__decap_3
XFILLER_61_405 VGND VGND VPWR VPWR sky130_fd_sc_hd__fill_1
XFILLER_92_77 VGND VGND VPWR VPWR sky130_fd_sc_hd__decap_6
Xclkbuf_leaf_53_clk clknet_3_6__leaf_clk VGND VGND VPWR VPWR clknet_leaf_53_clk sky130_fd_sc_hd__clkbuf_8
XFILLER_14_343 VGND VGND VPWR VPWR sky130_fd_sc_hd__decap_4
XFILLER_14_398 VPWR VGND VPWR VGND sky130_ef_sc_hd__decap_12
XFILLER_41_151 VGND VGND VPWR VPWR sky130_fd_sc_hd__decap_3
XFILLER_6_531 VGND VGND VPWR VPWR sky130_fd_sc_hd__fill_1
X_2360_ lsu.store_counter\[9\] _1609_ _1612_ lsu.store_counter\[8\] VGND VGND VPWR
+ VPWR _1799_ sky130_fd_sc_hd__o22ai_1
XFILLER_69_505 VPWR VGND VPWR VGND sky130_ef_sc_hd__decap_12
X_2291_ _1746_ _1748_ VGND VGND VPWR VPWR _0895_ sky130_fd_sc_hd__and2_1
XPHY_EDGE_ROW_10_Right_10 VGND VGND VPWR VPWR sky130_fd_sc_hd__decap_3
XFILLER_2_53 VPWR VGND VPWR VGND sky130_ef_sc_hd__decap_12
X_4030_ lsu.store_fifo.queue\[0\]\[7\] lsu.store_fifo.queue\[1\]\[7\] lsu.store_fifo.queue\[2\]\[7\]
+ lsu.store_fifo.queue\[3\]\[7\] net411 net406 VGND VGND VPWR VPWR _1468_ sky130_fd_sc_hd__mux4_1
XFILLER_92_563 VPWR VGND VPWR VGND sky130_ef_sc_hd__decap_12
XTAP_TAPCELL_ROW_35_614 VGND VPWR sky130_fd_sc_hd__tapvpwrvgnd_1
XTAP_TAPCELL_ROW_63_923 VGND VPWR sky130_fd_sc_hd__tapvpwrvgnd_1
Xclkbuf_leaf_44_clk clknet_3_7__leaf_clk VGND VGND VPWR VPWR clknet_leaf_44_clk sky130_fd_sc_hd__clkbuf_8
X_4932_ clknet_leaf_83_clk _0987_ VGND VGND VPWR VPWR lsu.load_fifo.queue\[13\]\[27\]
+ sky130_fd_sc_hd__dfxtp_1
X_4863_ clknet_leaf_41_clk _0918_ _0113_ VGND VGND VPWR VPWR lsu.load_counter\[13\]
+ sky130_fd_sc_hd__dfrtp_1
XTAP_TAPCELL_ROW_15_393 VGND VPWR sky130_fd_sc_hd__tapvpwrvgnd_1
X_3814_ _1281_ _1278_ net357 VGND VGND VPWR VPWR _1282_ sky130_fd_sc_hd__mux2_1
XFILLER_20_346 VGND VGND VPWR VPWR sky130_fd_sc_hd__fill_2
X_4794_ clknet_leaf_19_clk _0851_ VGND VGND VPWR VPWR lsu.load_fifo.data_in\[4\] sky130_fd_sc_hd__dfxtp_1
XFILLER_60_493 VGND VGND VPWR VPWR sky130_fd_sc_hd__fill_1
X_3745_ _1223_ _1224_ _1196_ VGND VGND VPWR VPWR _1227_ sky130_fd_sc_hd__a21o_1
Xoutput110 net110 VGND VGND VPWR VPWR load_addr[15] sky130_fd_sc_hd__buf_2
X_3676_ _1156_ _1157_ VGND VGND VPWR VPWR _1158_ sky130_fd_sc_hd__nand2_1
Xoutput121 net121 VGND VGND VPWR VPWR load_addr[5] sky130_fd_sc_hd__buf_2
X_2627_ _2003_ _2004_ VGND VGND VPWR VPWR _0710_ sky130_fd_sc_hd__or2_1
Xoutput143 net143 VGND VGND VPWR VPWR store_addr[4] sky130_fd_sc_hd__buf_2
Xoutput132 net132 VGND VGND VPWR VPWR store_addr[14] sky130_fd_sc_hd__buf_2
XFILLER_102_613 VGND VGND VPWR VPWR sky130_fd_sc_hd__decap_8
X_2558_ lsu.current_load_addr\[13\] _1927_ net259 VGND VGND VPWR VPWR _1956_ sky130_fd_sc_hd__a21oi_1
XTAP_TAPCELL_ROW_7_306 VGND VPWR sky130_fd_sc_hd__tapvpwrvgnd_1
Xoutput154 net154 VGND VGND VPWR VPWR store_data[5] sky130_fd_sc_hd__buf_2
XFILLER_87_335 VGND VGND VPWR VPWR sky130_fd_sc_hd__fill_1
X_2489_ net94 net267 _1905_ _1110_ VGND VGND VPWR VPWR _1906_ sky130_fd_sc_hd__a22o_1
X_4228_ clknet_leaf_53_clk _0285_ VGND VGND VPWR VPWR lsu.store_fifo.queue\[4\]\[6\]
+ sky130_fd_sc_hd__dfxtp_1
XFILLER_101_167 VGND VGND VPWR VPWR sky130_fd_sc_hd__fill_1
XPHY_EDGE_ROW_106_Right_106 VGND VGND VPWR VPWR sky130_fd_sc_hd__decap_3
XFILLER_83_530 VGND VGND VPWR VPWR sky130_fd_sc_hd__fill_1
X_4159_ clknet_leaf_9_clk _0216_ VGND VGND VPWR VPWR lsu.load_fifo.queue\[11\]\[19\]
+ sky130_fd_sc_hd__dfxtp_1
XTAP_TAPCELL_ROW_87_1188 VGND VPWR sky130_fd_sc_hd__tapvpwrvgnd_1
XFILLER_102_65 VPWR VGND VPWR VGND sky130_ef_sc_hd__decap_12
Xclkbuf_leaf_35_clk clknet_3_6__leaf_clk VGND VGND VPWR VPWR clknet_leaf_35_clk sky130_fd_sc_hd__clkbuf_8
Xwire237 _2051_ VGND VGND VPWR VPWR net237 sky130_fd_sc_hd__buf_8
XFILLER_87_55 VGND VGND VPWR VPWR sky130_fd_sc_hd__fill_1
XFILLER_93_305 VPWR VGND VPWR VGND sky130_ef_sc_hd__decap_12
XFILLER_19_413 VPWR VGND VPWR VGND sky130_ef_sc_hd__decap_12
Xfanout370 net373 VGND VGND VPWR VPWR net370 sky130_fd_sc_hd__clkbuf_4
Xfanout381 net382 VGND VGND VPWR VPWR net381 sky130_fd_sc_hd__clkbuf_2
Xfanout392 net399 VGND VGND VPWR VPWR net392 sky130_fd_sc_hd__clkbuf_4
XFILLER_93_349 VGND VGND VPWR VPWR sky130_fd_sc_hd__decap_4
XFILLER_46_265 VGND VGND VPWR VPWR sky130_fd_sc_hd__decap_4
Xclkbuf_leaf_26_clk clknet_3_2__leaf_clk VGND VGND VPWR VPWR clknet_leaf_26_clk sky130_fd_sc_hd__clkbuf_8
XFILLER_61_279 VGND VGND VPWR VPWR sky130_fd_sc_hd__fill_1
Xinput12 count[19] VGND VGND VPWR VPWR net12 sky130_fd_sc_hd__buf_1
XTAP_TAPCELL_ROW_12_363 VGND VPWR sky130_fd_sc_hd__tapvpwrvgnd_1
XTAP_TAPCELL_ROW_40_672 VGND VPWR sky130_fd_sc_hd__tapvpwrvgnd_1
Xinput23 count[9] VGND VGND VPWR VPWR net23 sky130_fd_sc_hd__clkbuf_2
Xinput34 load_base_addr[19] VGND VGND VPWR VPWR net34 sky130_fd_sc_hd__clkbuf_1
Xinput45 load_base_addr[9] VGND VGND VPWR VPWR net45 sky130_fd_sc_hd__clkbuf_1
X_3530_ net442 VGND VGND VPWR VPWR _0094_ sky130_fd_sc_hd__inv_2
Xhold807 lsu.current_load_addr\[20\] VGND VGND VPWR VPWR net1275 sky130_fd_sc_hd__dlygate4sd3_1
Xinput89 store_base_addr[18] VGND VGND VPWR VPWR net89 sky130_fd_sc_hd__clkbuf_1
Xinput67 load_data[28] VGND VGND VPWR VPWR net67 sky130_fd_sc_hd__clkbuf_1
XFILLER_10_390 VPWR VGND VPWR VGND sky130_ef_sc_hd__decap_12
Xinput78 load_data[9] VGND VGND VPWR VPWR net78 sky130_fd_sc_hd__clkbuf_1
Xinput56 load_data[18] VGND VGND VPWR VPWR net56 sky130_fd_sc_hd__clkbuf_1
Xhold818 acc.byte3\[4\] VGND VGND VPWR VPWR net1286 sky130_fd_sc_hd__dlygate4sd3_1
X_3461_ net428 VGND VGND VPWR VPWR _0025_ sky130_fd_sc_hd__inv_2
Xhold829 lsu.current_store_addr\[15\] VGND VGND VPWR VPWR net1297 sky130_fd_sc_hd__dlygate4sd3_1
XFILLER_6_394 VPWR VGND VPWR VGND sky130_ef_sc_hd__decap_12
XFILLER_42_3 VGND VGND VPWR VPWR sky130_fd_sc_hd__decap_8
X_2412_ _1847_ VGND VGND VPWR VPWR _1848_ sky130_fd_sc_hd__inv_2
X_3392_ net903 net338 net201 VGND VGND VPWR VPWR _1042_ sky130_fd_sc_hd__mux2_1
XFILLER_96_121 VPWR VGND VPWR VGND sky130_ef_sc_hd__decap_12
X_2343_ _1566_ lsu.store_counter\[19\] _1582_ VGND VGND VPWR VPWR _1782_ sky130_fd_sc_hd__and3_1
XFILLER_96_165 VPWR VGND VPWR VGND sky130_ef_sc_hd__decap_12
X_2274_ _1738_ _1737_ lsu.store_counter\[22\] VGND VGND VPWR VPWR _0902_ sky130_fd_sc_hd__mux2_1
XFILLER_69_379 VGND VGND VPWR VPWR sky130_fd_sc_hd__decap_8
X_4013_ lsu.store_fifo.queue\[12\]\[9\] lsu.store_fifo.queue\[13\]\[9\] lsu.store_fifo.queue\[14\]\[9\]
+ lsu.store_fifo.queue\[15\]\[9\] net413 net408 VGND VGND VPWR VPWR _1453_ sky130_fd_sc_hd__mux4_1
XFILLER_77_390 VGND VGND VPWR VPWR sky130_fd_sc_hd__fill_2
XTAP_TAPCELL_ROW_48_761 VGND VPWR sky130_fd_sc_hd__tapvpwrvgnd_1
XFILLER_25_449 VGND VGND VPWR VPWR sky130_fd_sc_hd__decap_4
XFILLER_52_213 VGND VGND VPWR VPWR sky130_fd_sc_hd__fill_1
Xclkbuf_leaf_17_clk clknet_3_2__leaf_clk VGND VGND VPWR VPWR clknet_leaf_17_clk sky130_fd_sc_hd__clkbuf_8
X_4915_ clknet_leaf_24_clk _0970_ VGND VGND VPWR VPWR lsu.load_fifo.queue\[13\]\[10\]
+ sky130_fd_sc_hd__dfxtp_1
XFILLER_40_419 VGND VGND VPWR VPWR sky130_fd_sc_hd__fill_1
X_4846_ clknet_leaf_52_clk _0001_ _0096_ VGND VGND VPWR VPWR lsu.store_fifo.w_en sky130_fd_sc_hd__dfrtp_1
X_4777_ clknet_leaf_37_clk _0834_ _0069_ VGND VGND VPWR VPWR lsu.load_fifo.w_en sky130_fd_sc_hd__dfrtp_1
X_3728_ _1207_ _1209_ VGND VGND VPWR VPWR _1210_ sky130_fd_sc_hd__nand2_1
X_3659_ acc.byte1\[1\] acc.byte0\[1\] VGND VGND VPWR VPWR _1141_ sky130_fd_sc_hd__nand2_1
XFILLER_102_487 VGND VGND VPWR VPWR sky130_fd_sc_hd__decap_8
XTAP_TAPCELL_ROW_89_1206 VGND VPWR sky130_fd_sc_hd__tapvpwrvgnd_1
XFILLER_75_349 VGND VGND VPWR VPWR sky130_fd_sc_hd__fill_1
XFILLER_83_393 VPWR VGND VPWR VGND sky130_ef_sc_hd__decap_12
XFILLER_28_298 VGND VGND VPWR VPWR sky130_fd_sc_hd__decap_6
XFILLER_73_57 VGND VGND VPWR VPWR sky130_fd_sc_hd__decap_3
XFILLER_24_471 VGND VGND VPWR VPWR sky130_fd_sc_hd__decap_4
XFILLER_43_279 VGND VGND VPWR VPWR sky130_fd_sc_hd__fill_1
XFILLER_11_121 VGND VGND VPWR VPWR sky130_fd_sc_hd__decap_3
XFILLER_7_103 VGND VGND VPWR VPWR sky130_fd_sc_hd__fill_1
XFILLER_98_419 VGND VGND VPWR VPWR sky130_fd_sc_hd__fill_1
XFILLER_98_65 VPWR VGND VPWR VGND sky130_ef_sc_hd__decap_12
XFILLER_93_113 VPWR VGND VPWR VGND sky130_ef_sc_hd__decap_12
XFILLER_66_338 VGND VGND VPWR VPWR sky130_fd_sc_hd__decap_8
XFILLER_74_393 VPWR VGND VPWR VGND sky130_ef_sc_hd__decap_12
XTAP_TAPCELL_ROW_45_720 VGND VPWR sky130_fd_sc_hd__tapvpwrvgnd_1
XFILLER_62_533 VGND VGND VPWR VPWR sky130_fd_sc_hd__decap_8
XTAP_TAPCELL_ROW_17_422 VGND VPWR sky130_fd_sc_hd__tapvpwrvgnd_1
X_2961_ net309 net1154 net215 VGND VGND VPWR VPWR _0472_ sky130_fd_sc_hd__mux2_1
X_4700_ clknet_leaf_61_clk _0757_ VGND VGND VPWR VPWR lsu.store_fifo.queue\[14\]\[4\]
+ sky130_fd_sc_hd__dfxtp_1
X_2892_ net588 net314 net193 VGND VGND VPWR VPWR _0403_ sky130_fd_sc_hd__mux2_1
X_4631_ clknet_leaf_13_clk _0688_ VGND VGND VPWR VPWR lsu.load_fifo.queue\[15\]\[15\]
+ sky130_fd_sc_hd__dfxtp_1
X_4562_ clknet_leaf_22_clk _0619_ VGND VGND VPWR VPWR lsu.load_fifo.queue\[0\]\[10\]
+ sky130_fd_sc_hd__dfxtp_1
X_3513_ net436 VGND VGND VPWR VPWR _0077_ sky130_fd_sc_hd__inv_2
Xhold604 lsu.load_fifo.queue\[15\]\[25\] VGND VGND VPWR VPWR net1072 sky130_fd_sc_hd__dlygate4sd3_1
Xhold615 lsu.load_fifo.queue\[7\]\[18\] VGND VGND VPWR VPWR net1083 sky130_fd_sc_hd__dlygate4sd3_1
X_4493_ clknet_leaf_6_clk _0550_ VGND VGND VPWR VPWR lsu.load_fifo.queue\[2\]\[5\]
+ sky130_fd_sc_hd__dfxtp_1
Xhold626 lsu.load_fifo.queue\[14\]\[30\] VGND VGND VPWR VPWR net1094 sky130_fd_sc_hd__dlygate4sd3_1
X_3444_ net435 VGND VGND VPWR VPWR _0008_ sky130_fd_sc_hd__inv_2
XTAP_TAPCELL_ROW_73_1029 VGND VPWR sky130_fd_sc_hd__tapvpwrvgnd_1
Xhold648 lsu.store_fifo.queue\[13\]\[9\] VGND VGND VPWR VPWR net1116 sky130_fd_sc_hd__dlygate4sd3_1
Xhold659 lsu.load_fifo.queue\[7\]\[13\] VGND VGND VPWR VPWR net1127 sky130_fd_sc_hd__dlygate4sd3_1
Xclkbuf_leaf_6_clk clknet_3_0__leaf_clk VGND VGND VPWR VPWR clknet_leaf_6_clk sky130_fd_sc_hd__clkbuf_8
Xhold637 lsu.store_fifo.queue\[5\]\[8\] VGND VGND VPWR VPWR net1105 sky130_fd_sc_hd__dlygate4sd3_1
X_3375_ net307 net1186 net172 VGND VGND VPWR VPWR _0984_ sky130_fd_sc_hd__mux2_1
XFILLER_69_132 VGND VGND VPWR VPWR sky130_fd_sc_hd__decap_4
X_2326_ net1288 _1769_ _1767_ VGND VGND VPWR VPWR _0881_ sky130_fd_sc_hd__o21a_1
XFILLER_69_165 VGND VGND VPWR VPWR sky130_fd_sc_hd__decap_3
XFILLER_57_305 VGND VGND VPWR VPWR sky130_fd_sc_hd__decap_6
X_2257_ _1716_ _1721_ VGND VGND VPWR VPWR _1722_ sky130_fd_sc_hd__and2_1
XFILLER_57_349 VGND VGND VPWR VPWR sky130_fd_sc_hd__decap_8
X_2188_ net167 net164 _1677_ net263 net244 VGND VGND VPWR VPWR _1678_ sky130_fd_sc_hd__o221a_1
XTAP_TAPCELL_ROW_84_1158 VGND VPWR sky130_fd_sc_hd__tapvpwrvgnd_1
Xclone15 _1679_ VGND VGND VPWR VPWR net483 sky130_fd_sc_hd__buf_6
XTAP_TAPCELL_ROW_51_789 VGND VPWR sky130_fd_sc_hd__tapvpwrvgnd_1
X_4829_ clknet_leaf_36_clk _0886_ _0079_ VGND VGND VPWR VPWR lsu.store_counter\[6\]
+ sky130_fd_sc_hd__dfrtp_1
XFILLER_5_629 VGND VGND VPWR VPWR sky130_fd_sc_hd__fill_1
XFILLER_4_139 VGND VGND VPWR VPWR sky130_fd_sc_hd__fill_1
XTAP_TAPCELL_ROW_95_1276 VGND VPWR sky130_fd_sc_hd__tapvpwrvgnd_1
XFILLER_0_345 VGND VGND VPWR VPWR sky130_fd_sc_hd__fill_1
XFILLER_102_251 VGND VGND VPWR VPWR sky130_fd_sc_hd__fill_1
XFILLER_75_102 VGND VGND VPWR VPWR sky130_fd_sc_hd__fill_2
XFILLER_0_356 VGND VGND VPWR VPWR sky130_fd_sc_hd__decap_8
XFILLER_0_389 VGND VGND VPWR VPWR sky130_fd_sc_hd__decap_3
XFILLER_48_349 VGND VGND VPWR VPWR sky130_fd_sc_hd__fill_1
XTAP_TAPCELL_ROW_59_878 VGND VPWR sky130_fd_sc_hd__tapvpwrvgnd_1
XFILLER_90_138 VGND VGND VPWR VPWR sky130_fd_sc_hd__fill_2
XFILLER_44_533 VPWR VGND VPWR VGND sky130_ef_sc_hd__decap_12
XFILLER_56_371 VPWR VGND VPWR VGND sky130_ef_sc_hd__decap_12
XTAP_TAPCELL_ROW_104_1372 VGND VPWR sky130_fd_sc_hd__tapvpwrvgnd_1
XFILLER_8_445 VPWR VGND VPWR VGND sky130_ef_sc_hd__decap_12
XFILLER_8_489 VPWR VGND VPWR VGND sky130_ef_sc_hd__decap_12
X_3160_ net808 net313 net179 VGND VGND VPWR VPWR _0662_ sky130_fd_sc_hd__mux2_1
XFILLER_66_102 VGND VGND VPWR VPWR sky130_fd_sc_hd__decap_6
X_2111_ _1561_ _1600_ VGND VGND VPWR VPWR _1601_ sky130_fd_sc_hd__and2_1
X_3091_ net318 net1192 net185 VGND VGND VPWR VPWR _0595_ sky130_fd_sc_hd__mux2_1
XFILLER_47_360 VGND VGND VPWR VPWR sky130_fd_sc_hd__decap_8
XFILLER_66_179 VPWR VGND VPWR VGND sky130_ef_sc_hd__decap_12
XFILLER_35_555 VGND VGND VPWR VPWR sky130_fd_sc_hd__decap_4
XFILLER_47_393 VGND VGND VPWR VPWR sky130_fd_sc_hd__fill_2
XPHY_EDGE_ROW_8_Right_8 VGND VGND VPWR VPWR sky130_fd_sc_hd__decap_3
XFILLER_62_363 VGND VGND VPWR VPWR sky130_fd_sc_hd__fill_1
XFILLER_22_238 VPWR VGND VPWR VGND sky130_ef_sc_hd__decap_12
X_3993_ acc.byte0\[1\] _1434_ net254 VGND VGND VPWR VPWR _1003_ sky130_fd_sc_hd__mux2_1
XFILLER_15_290 VGND VGND VPWR VPWR sky130_fd_sc_hd__decap_4
X_2944_ net342 net1133 net214 VGND VGND VPWR VPWR _0455_ sky130_fd_sc_hd__mux2_1
X_2875_ net972 net348 net193 VGND VGND VPWR VPWR _0386_ sky130_fd_sc_hd__mux2_1
X_4614_ clknet_leaf_12_clk _0671_ VGND VGND VPWR VPWR lsu.load_fifo.queue\[8\]\[30\]
+ sky130_fd_sc_hd__dfxtp_1
X_4545_ clknet_leaf_68_clk _0602_ VGND VGND VPWR VPWR lsu.load_fifo.queue\[1\]\[25\]
+ sky130_fd_sc_hd__dfxtp_1
Xhold401 lsu.load_fifo.queue\[2\]\[4\] VGND VGND VPWR VPWR net869 sky130_fd_sc_hd__dlygate4sd3_1
Xhold423 lsu.load_fifo.queue\[2\]\[7\] VGND VGND VPWR VPWR net891 sky130_fd_sc_hd__dlygate4sd3_1
Xhold445 lsu.load_fifo.queue\[8\]\[11\] VGND VGND VPWR VPWR net913 sky130_fd_sc_hd__dlygate4sd3_1
Xhold412 lsu.load_fifo.queue\[3\]\[14\] VGND VGND VPWR VPWR net880 sky130_fd_sc_hd__dlygate4sd3_1
Xhold434 lsu.load_fifo.queue\[6\]\[15\] VGND VGND VPWR VPWR net902 sky130_fd_sc_hd__dlygate4sd3_1
Xhold456 net139 VGND VGND VPWR VPWR net924 sky130_fd_sc_hd__dlygate4sd3_1
Xhold478 net132 VGND VGND VPWR VPWR net946 sky130_fd_sc_hd__dlygate4sd3_1
Xhold467 lsu.load_fifo.queue\[1\]\[20\] VGND VGND VPWR VPWR net935 sky130_fd_sc_hd__dlygate4sd3_1
X_4476_ clknet_leaf_85_clk _0533_ VGND VGND VPWR VPWR lsu.load_fifo.queue\[3\]\[20\]
+ sky130_fd_sc_hd__dfxtp_1
XFILLER_89_249 VPWR VGND VPWR VGND sky130_ef_sc_hd__decap_12
Xmax_cap197 _1787_ VGND VGND VPWR VPWR net197 sky130_fd_sc_hd__clkbuf_1
XPHY_EDGE_ROW_39_Right_39 VGND VGND VPWR VPWR sky130_fd_sc_hd__decap_3
Xhold489 lsu.load_fifo.queue\[2\]\[26\] VGND VGND VPWR VPWR net957 sky130_fd_sc_hd__dlygate4sd3_1
X_3427_ _2024_ _2048_ VGND VGND VPWR VPWR _2059_ sky130_fd_sc_hd__nor2_4
X_3358_ net340 net960 net172 VGND VGND VPWR VPWR _0967_ sky130_fd_sc_hd__mux2_1
XFILLER_97_293 VPWR VGND VPWR VGND sky130_ef_sc_hd__decap_12
XFILLER_85_433 VGND VGND VPWR VPWR sky130_fd_sc_hd__fill_2
X_2309_ lsu.store_counter\[8\] _1758_ _1759_ _1728_ VGND VGND VPWR VPWR _0888_ sky130_fd_sc_hd__a22o_1
XFILLER_38_38 VGND VGND VPWR VPWR sky130_fd_sc_hd__decap_6
XFILLER_57_113 VGND VGND VPWR VPWR sky130_fd_sc_hd__fill_1
XFILLER_57_146 VGND VGND VPWR VPWR sky130_fd_sc_hd__decap_3
X_3289_ net346 net73 net250 VGND VGND VPWR VPWR _0851_ sky130_fd_sc_hd__mux2_1
XFILLER_26_522 VGND VGND VPWR VPWR sky130_fd_sc_hd__decap_8
XTAP_TAPCELL_ROW_28_539 VGND VPWR sky130_fd_sc_hd__tapvpwrvgnd_1
X_5028_ clknet_leaf_72_clk _1083_ _0172_ VGND VGND VPWR VPWR acc.data_out\[7\] sky130_fd_sc_hd__dfrtp_1
XTAP_TAPCELL_ROW_56_848 VGND VPWR sky130_fd_sc_hd__tapvpwrvgnd_1
XFILLER_26_533 VPWR VGND VPWR VGND sky130_ef_sc_hd__decap_12
XFILLER_53_330 VGND VGND VPWR VPWR sky130_fd_sc_hd__decap_6
XPHY_EDGE_ROW_48_Right_48 VGND VGND VPWR VPWR sky130_fd_sc_hd__decap_3
XPHY_EDGE_ROW_57_Right_57 VGND VGND VPWR VPWR sky130_fd_sc_hd__decap_3
XFILLER_95_55 VGND VGND VPWR VPWR sky130_fd_sc_hd__fill_1
XFILLER_0_197 VPWR VGND VPWR VGND sky130_ef_sc_hd__decap_12
XFILLER_76_477 VPWR VGND VPWR VGND sky130_ef_sc_hd__decap_12
XFILLER_48_146 VPWR VGND VPWR VGND sky130_ef_sc_hd__decap_12
XTAP_TAPCELL_ROW_106_1401 VGND VPWR sky130_fd_sc_hd__tapvpwrvgnd_1
XFILLER_91_414 VGND VGND VPWR VPWR sky130_fd_sc_hd__decap_4
XFILLER_28_82 VGND VGND VPWR VPWR sky130_fd_sc_hd__fill_2
XTAP_TAPCELL_ROW_106_1412 VGND VPWR sky130_fd_sc_hd__tapvpwrvgnd_1
XFILLER_29_393 VGND VGND VPWR VPWR sky130_fd_sc_hd__fill_1
XPHY_EDGE_ROW_66_Right_66 VGND VGND VPWR VPWR sky130_fd_sc_hd__decap_3
XFILLER_44_363 VGND VGND VPWR VPWR sky130_fd_sc_hd__fill_1
X_2660_ lsu.store_fifo.w_ptr\[0\] _2011_ lsu.store_fifo.w_ptr\[1\] VGND VGND VPWR
+ VPWR _2020_ sky130_fd_sc_hd__nand3b_4
X_2591_ lsu.current_load_addr\[4\] _1921_ VGND VGND VPWR VPWR _1980_ sky130_fd_sc_hd__or2_1
XPHY_EDGE_ROW_75_Right_75 VGND VGND VPWR VPWR sky130_fd_sc_hd__decap_3
X_4330_ clknet_leaf_5_clk _0387_ VGND VGND VPWR VPWR lsu.load_fifo.queue\[7\]\[4\]
+ sky130_fd_sc_hd__dfxtp_1
X_4261_ clknet_leaf_70_clk _0318_ VGND VGND VPWR VPWR lsu.store_fifo.queue\[1\]\[9\]
+ sky130_fd_sc_hd__dfxtp_1
X_3212_ net278 net904 _2049_ VGND VGND VPWR VPWR _0723_ sky130_fd_sc_hd__mux2_1
X_4192_ clknet_leaf_53_clk _0249_ VGND VGND VPWR VPWR lsu.store_fifo.queue\[7\]\[0\]
+ sky130_fd_sc_hd__dfxtp_1
X_3143_ net593 net347 net179 VGND VGND VPWR VPWR _0645_ sky130_fd_sc_hd__mux2_1
XPHY_EDGE_ROW_84_Right_84 VGND VGND VPWR VPWR sky130_fd_sc_hd__decap_3
X_3074_ net352 net1029 net185 VGND VGND VPWR VPWR _0578_ sky130_fd_sc_hd__mux2_1
XTAP_TAPCELL_ROW_25_509 VGND VPWR sky130_fd_sc_hd__tapvpwrvgnd_1
XTAP_TAPCELL_ROW_53_818 VGND VPWR sky130_fd_sc_hd__tapvpwrvgnd_1
XTAP_TAPCELL_ROW_81_1117 VGND VPWR sky130_fd_sc_hd__tapvpwrvgnd_1
XFILLER_24_29 VGND VGND VPWR VPWR sky130_fd_sc_hd__decap_3
XFILLER_50_322 VPWR VGND VPWR VGND sky130_ef_sc_hd__decap_12
X_3976_ lsu.load_fifo.queue\[4\]\[3\] lsu.load_fifo.queue\[5\]\[3\] lsu.load_fifo.queue\[6\]\[3\]
+ lsu.load_fifo.queue\[7\]\[3\] net383 net366 VGND VGND VPWR VPWR _1420_ sky130_fd_sc_hd__mux4_1
X_2927_ net1184 net310 net219 VGND VGND VPWR VPWR _0439_ sky130_fd_sc_hd__mux2_1
XTAP_TAPCELL_ROW_33_597 VGND VPWR sky130_fd_sc_hd__tapvpwrvgnd_1
XPHY_EDGE_ROW_93_Right_93 VGND VGND VPWR VPWR sky130_fd_sc_hd__decap_3
X_2858_ net914 net319 net222 VGND VGND VPWR VPWR _0369_ sky130_fd_sc_hd__mux2_1
Xhold220 lsu.load_fifo.queue\[3\]\[7\] VGND VGND VPWR VPWR net688 sky130_fd_sc_hd__dlygate4sd3_1
X_2789_ net837 net281 _2031_ VGND VGND VPWR VPWR _0304_ sky130_fd_sc_hd__mux2_1
Xhold253 net145 VGND VGND VPWR VPWR net721 sky130_fd_sc_hd__dlygate4sd3_1
Xhold231 net135 VGND VGND VPWR VPWR net699 sky130_fd_sc_hd__dlygate4sd3_1
XFILLER_2_418 VGND VGND VPWR VPWR sky130_fd_sc_hd__fill_2
Xhold242 lsu.load_fifo.queue\[2\]\[30\] VGND VGND VPWR VPWR net710 sky130_fd_sc_hd__dlygate4sd3_1
X_4528_ clknet_leaf_34_clk _0585_ VGND VGND VPWR VPWR lsu.load_fifo.queue\[1\]\[8\]
+ sky130_fd_sc_hd__dfxtp_1
XTAP_TAPCELL_ROW_92_1246 VGND VPWR sky130_fd_sc_hd__tapvpwrvgnd_1
Xhold264 lsu.load_fifo.queue\[10\]\[7\] VGND VGND VPWR VPWR net732 sky130_fd_sc_hd__dlygate4sd3_1
X_4459_ clknet_leaf_87_clk _0516_ VGND VGND VPWR VPWR lsu.load_fifo.queue\[3\]\[3\]
+ sky130_fd_sc_hd__dfxtp_1
Xhold275 lsu.load_fifo.queue\[8\]\[31\] VGND VGND VPWR VPWR net743 sky130_fd_sc_hd__dlygate4sd3_1
Xhold286 lsu.store_fifo.queue\[1\]\[0\] VGND VGND VPWR VPWR net754 sky130_fd_sc_hd__dlygate4sd3_1
Xhold297 lsu.store_fifo.queue\[10\]\[5\] VGND VGND VPWR VPWR net765 sky130_fd_sc_hd__dlygate4sd3_1
XFILLER_98_580 VGND VGND VPWR VPWR sky130_fd_sc_hd__decap_8
XFILLER_105_54 VGND VGND VPWR VPWR sky130_fd_sc_hd__fill_2
XFILLER_100_541 VGND VGND VPWR VPWR sky130_fd_sc_hd__decap_3
XTAP_TAPCELL_ROW_5_289 VGND VPWR sky130_fd_sc_hd__tapvpwrvgnd_1
XFILLER_73_436 VPWR VGND VPWR VGND sky130_ef_sc_hd__decap_12
XTAP_TAPCELL_ROW_69_984 VGND VPWR sky130_fd_sc_hd__tapvpwrvgnd_1
XFILLER_58_477 VGND VGND VPWR VPWR sky130_fd_sc_hd__fill_1
XFILLER_38_190 VGND VGND VPWR VPWR sky130_fd_sc_hd__decap_6
XFILLER_14_525 VGND VGND VPWR VPWR sky130_fd_sc_hd__decap_6
XFILLER_81_57 VGND VGND VPWR VPWR sky130_fd_sc_hd__fill_2
XFILLER_14_569 VPWR VGND VPWR VGND sky130_ef_sc_hd__decap_12
XTAP_TAPCELL_ROW_101_1342 VGND VPWR sky130_fd_sc_hd__tapvpwrvgnd_1
XFILLER_1_473 VPWR VGND VPWR VGND sky130_ef_sc_hd__decap_12
XFILLER_49_466 VGND VGND VPWR VPWR sky130_fd_sc_hd__decap_6
XFILLER_49_499 VGND VGND VPWR VPWR sky130_fd_sc_hd__decap_4
X_3830_ lsu.load_fifo.queue\[4\]\[24\] lsu.load_fifo.queue\[5\]\[24\] lsu.load_fifo.queue\[6\]\[24\]
+ lsu.load_fifo.queue\[7\]\[24\] net397 net380 VGND VGND VPWR VPWR _1295_ sky130_fd_sc_hd__mux4_1
X_3761_ _1223_ _1225_ VGND VGND VPWR VPWR _1238_ sky130_fd_sc_hd__nand2b_1
X_2712_ net279 net1057 _2023_ VGND VGND VPWR VPWR _0235_ sky130_fd_sc_hd__mux2_1
XFILLER_9_573 VPWR VGND VPWR VGND sky130_ef_sc_hd__decap_12
XTAP_TAPCELL_ROW_30_556 VGND VPWR sky130_fd_sc_hd__tapvpwrvgnd_1
X_3692_ acc.byte3\[5\] acc.byte2\[5\] VGND VGND VPWR VPWR _1174_ sky130_fd_sc_hd__or2_1
X_2643_ net1293 _2013_ VGND VGND VPWR VPWR _0707_ sky130_fd_sc_hd__xnor2_1
X_2574_ net261 _1925_ VGND VGND VPWR VPWR _1968_ sky130_fd_sc_hd__nor2_1
XTAP_TAPCELL_ROW_78_1090 VGND VPWR sky130_fd_sc_hd__tapvpwrvgnd_1
X_4313_ clknet_leaf_8_clk _0370_ VGND VGND VPWR VPWR lsu.load_fifo.queue\[10\]\[19\]
+ sky130_fd_sc_hd__dfxtp_1
XFILLER_87_517 VPWR VGND VPWR VGND sky130_ef_sc_hd__decap_12
XFILLER_101_316 VGND VGND VPWR VPWR sky130_fd_sc_hd__fill_1
XFILLER_99_399 VGND VGND VPWR VPWR sky130_fd_sc_hd__fill_2
X_4244_ clknet_leaf_57_clk _0301_ VGND VGND VPWR VPWR lsu.store_fifo.queue\[2\]\[2\]
+ sky130_fd_sc_hd__dfxtp_1
XFILLER_101_349 VGND VGND VPWR VPWR sky130_fd_sc_hd__fill_1
X_4175_ clknet_leaf_67_clk _0232_ VGND VGND VPWR VPWR lsu.store_fifo.queue\[9\]\[3\]
+ sky130_fd_sc_hd__dfxtp_1
X_3126_ net577 net314 net181 VGND VGND VPWR VPWR _0629_ sky130_fd_sc_hd__mux2_1
XFILLER_28_628 VGND VGND VPWR VPWR sky130_fd_sc_hd__fill_2
XTAP_TAPCELL_ROW_2_248 VGND VPWR sky130_fd_sc_hd__tapvpwrvgnd_1
XTAP_TAPCELL_ROW_38_645 VGND VPWR sky130_fd_sc_hd__tapvpwrvgnd_1
XFILLER_55_436 VPWR VGND VPWR VGND sky130_ef_sc_hd__decap_12
XTAP_TAPCELL_ROW_66_954 VGND VPWR sky130_fd_sc_hd__tapvpwrvgnd_1
X_3057_ net741 net320 net207 VGND VGND VPWR VPWR _0562_ sky130_fd_sc_hd__mux2_1
XFILLER_42_119 VGND VGND VPWR VPWR sky130_fd_sc_hd__decap_3
XFILLER_50_141 VGND VGND VPWR VPWR sky130_fd_sc_hd__decap_6
XFILLER_11_517 VPWR VGND VPWR VGND sky130_ef_sc_hd__decap_12
XFILLER_23_388 VGND VGND VPWR VPWR sky130_fd_sc_hd__decap_4
X_3959_ _1405_ _1404_ net360 VGND VGND VPWR VPWR _1406_ sky130_fd_sc_hd__mux2_1
XFILLER_105_600 VPWR VGND VPWR VGND sky130_ef_sc_hd__decap_12
XFILLER_19_617 VPWR VGND VPWR VGND sky130_ef_sc_hd__decap_12
XFILLER_46_414 VGND VGND VPWR VPWR sky130_fd_sc_hd__decap_6
XFILLER_58_274 VGND VGND VPWR VPWR sky130_fd_sc_hd__decap_6
XFILLER_14_333 VGND VGND VPWR VPWR sky130_fd_sc_hd__fill_1
XFILLER_25_50 VGND VGND VPWR VPWR sky130_fd_sc_hd__decap_6
XFILLER_6_587 VGND VGND VPWR VPWR sky130_fd_sc_hd__fill_1
XFILLER_69_517 VPWR VGND VPWR VGND sky130_ef_sc_hd__decap_12
X_2290_ lsu.store_counter\[14\] net239 _1731_ lsu.store_counter\[15\] VGND VGND VPWR
+ VPWR _1748_ sky130_fd_sc_hd__a31o_1
XFILLER_1_281 VGND VGND VPWR VPWR sky130_fd_sc_hd__fill_1
XFILLER_49_241 VGND VGND VPWR VPWR sky130_fd_sc_hd__decap_3
XFILLER_77_561 VPWR VGND VPWR VGND sky130_ef_sc_hd__decap_12
XFILLER_2_65 VPWR VGND VPWR VGND sky130_ef_sc_hd__decap_12
XFILLER_37_447 VGND VGND VPWR VPWR sky130_fd_sc_hd__fill_1
XFILLER_92_575 VPWR VGND VPWR VGND sky130_ef_sc_hd__decap_12
XFILLER_92_597 VGND VGND VPWR VPWR sky130_fd_sc_hd__decap_3
XTAP_TAPCELL_ROW_35_615 VGND VPWR sky130_fd_sc_hd__tapvpwrvgnd_1
X_4931_ clknet_leaf_17_clk _0986_ VGND VGND VPWR VPWR lsu.load_fifo.queue\[13\]\[26\]
+ sky130_fd_sc_hd__dfxtp_1
XTAP_TAPCELL_ROW_63_924 VGND VPWR sky130_fd_sc_hd__tapvpwrvgnd_1
X_4862_ clknet_leaf_42_clk _0917_ _0112_ VGND VGND VPWR VPWR lsu.load_counter\[12\]
+ sky130_fd_sc_hd__dfrtp_1
XFILLER_32_141 VGND VGND VPWR VPWR sky130_fd_sc_hd__fill_2
X_3813_ _1280_ _1279_ net361 VGND VGND VPWR VPWR _1281_ sky130_fd_sc_hd__mux2_1
XTAP_TAPCELL_ROW_15_394 VGND VPWR sky130_fd_sc_hd__tapvpwrvgnd_1
X_4793_ clknet_leaf_87_clk _0850_ VGND VGND VPWR VPWR lsu.load_fifo.data_in\[3\] sky130_fd_sc_hd__dfxtp_1
X_3744_ _1225_ _1223_ VGND VGND VPWR VPWR _1226_ sky130_fd_sc_hd__nand2b_1
X_3675_ acc.byte3\[7\] acc.byte2\[7\] VGND VGND VPWR VPWR _1157_ sky130_fd_sc_hd__or2_1
X_2626_ lsu.load_fifo.w_ptr\[1\] _1997_ VGND VGND VPWR VPWR _2004_ sky130_fd_sc_hd__and2_1
Xoutput111 net111 VGND VGND VPWR VPWR load_addr[16] sky130_fd_sc_hd__buf_2
Xoutput122 net122 VGND VGND VPWR VPWR load_addr[6] sky130_fd_sc_hd__buf_2
Xoutput133 net133 VGND VGND VPWR VPWR store_addr[15] sky130_fd_sc_hd__buf_2
X_2557_ lsu.current_load_addr\[13\] _1927_ VGND VGND VPWR VPWR _1955_ sky130_fd_sc_hd__or2_1
XTAP_TAPCELL_ROW_7_307 VGND VPWR sky130_fd_sc_hd__tapvpwrvgnd_1
Xoutput155 net155 VGND VGND VPWR VPWR store_data[6] sky130_fd_sc_hd__buf_2
Xoutput144 net144 VGND VGND VPWR VPWR store_addr[5] sky130_fd_sc_hd__buf_2
X_2488_ net267 _1840_ VGND VGND VPWR VPWR _1905_ sky130_fd_sc_hd__nor2_1
X_4227_ clknet_leaf_71_clk _0284_ VGND VGND VPWR VPWR lsu.store_fifo.queue\[4\]\[5\]
+ sky130_fd_sc_hd__dfxtp_1
XFILLER_28_414 VGND VGND VPWR VPWR sky130_fd_sc_hd__decap_6
XFILLER_95_391 VGND VGND VPWR VPWR sky130_fd_sc_hd__fill_1
X_4158_ clknet_leaf_84_clk _0215_ VGND VGND VPWR VPWR lsu.load_fifo.queue\[11\]\[18\]
+ sky130_fd_sc_hd__dfxtp_1
XFILLER_83_586 VGND VGND VPWR VPWR sky130_fd_sc_hd__decap_4
XFILLER_83_553 VGND VGND VPWR VPWR sky130_fd_sc_hd__fill_1
X_3109_ net708 net349 net181 VGND VGND VPWR VPWR _0612_ sky130_fd_sc_hd__mux2_1
XFILLER_28_469 VGND VGND VPWR VPWR sky130_fd_sc_hd__decap_6
X_4089_ lsu.store_fifo.queue\[4\]\[2\] lsu.store_fifo.queue\[5\]\[2\] lsu.store_fifo.queue\[6\]\[2\]
+ lsu.store_fifo.queue\[7\]\[2\] net413 net406 VGND VGND VPWR VPWR _1522_ sky130_fd_sc_hd__mux4_1
XFILLER_55_277 VGND VGND VPWR VPWR sky130_fd_sc_hd__decap_3
XTAP_TAPCELL_ROW_87_1189 VGND VPWR sky130_fd_sc_hd__tapvpwrvgnd_1
XFILLER_43_439 VGND VGND VPWR VPWR sky130_fd_sc_hd__fill_1
XFILLER_102_77 VGND VGND VPWR VPWR sky130_fd_sc_hd__decap_6
XFILLER_2_3 VPWR VGND VPWR VGND sky130_ef_sc_hd__decap_12
XFILLER_93_317 VPWR VGND VPWR VGND sky130_ef_sc_hd__decap_12
Xfanout393 net399 VGND VGND VPWR VPWR net393 sky130_fd_sc_hd__buf_4
Xfanout371 net373 VGND VGND VPWR VPWR net371 sky130_fd_sc_hd__clkbuf_4
Xfanout360 net362 VGND VGND VPWR VPWR net360 sky130_fd_sc_hd__buf_4
Xfanout382 lsu.load_fifo.r_ptr\[1\] VGND VGND VPWR VPWR net382 sky130_fd_sc_hd__buf_2
XFILLER_19_425 VGND VGND VPWR VPWR sky130_fd_sc_hd__fill_2
XFILLER_74_564 VGND VGND VPWR VPWR sky130_fd_sc_hd__decap_3
XFILLER_14_141 VGND VGND VPWR VPWR sky130_fd_sc_hd__decap_3
Xinput13 count[1] VGND VGND VPWR VPWR net13 sky130_fd_sc_hd__buf_1
Xinput46 load_complete VGND VGND VPWR VPWR net46 sky130_fd_sc_hd__buf_1
Xinput35 load_base_addr[1] VGND VGND VPWR VPWR net35 sky130_fd_sc_hd__clkbuf_1
Xinput24 load_base_addr[0] VGND VGND VPWR VPWR net24 sky130_fd_sc_hd__clkbuf_1
XTAP_TAPCELL_ROW_12_364 VGND VPWR sky130_fd_sc_hd__tapvpwrvgnd_1
XTAP_TAPCELL_ROW_40_673 VGND VPWR sky130_fd_sc_hd__tapvpwrvgnd_1
Xinput79 start VGND VGND VPWR VPWR net79 sky130_fd_sc_hd__clkbuf_2
Xhold808 net126 VGND VGND VPWR VPWR net1276 sky130_fd_sc_hd__dlygate4sd3_1
Xinput68 load_data[29] VGND VGND VPWR VPWR net68 sky130_fd_sc_hd__clkbuf_1
Xinput57 load_data[19] VGND VGND VPWR VPWR net57 sky130_fd_sc_hd__clkbuf_1
Xhold819 acc.byte2\[2\] VGND VGND VPWR VPWR net1287 sky130_fd_sc_hd__dlygate4sd3_1
X_3460_ net428 VGND VGND VPWR VPWR _0024_ sky130_fd_sc_hd__inv_2
XTAP_TAPCELL_ROW_75_1060 VGND VPWR sky130_fd_sc_hd__tapvpwrvgnd_1
X_3391_ net1207 net340 net201 VGND VGND VPWR VPWR _1041_ sky130_fd_sc_hd__mux2_1
X_2411_ lsu.current_store_addr\[8\] lsu.current_store_addr\[7\] _1846_ VGND VGND VPWR
+ VPWR _1847_ sky130_fd_sc_hd__and3_1
X_2342_ lsu.store_counter\[20\] _1568_ _1779_ _1780_ VGND VGND VPWR VPWR _1781_ sky130_fd_sc_hd__a211oi_1
XFILLER_35_3 VGND VGND VPWR VPWR sky130_fd_sc_hd__fill_2
XFILLER_96_133 VGND VGND VPWR VPWR sky130_fd_sc_hd__decap_6
XFILLER_96_177 VPWR VGND VPWR VGND sky130_ef_sc_hd__decap_12
X_2273_ lsu.store_counter\[21\] _1720_ _1735_ VGND VGND VPWR VPWR _1738_ sky130_fd_sc_hd__and3_1
X_4012_ lsu.store_fifo.queue\[4\]\[9\] lsu.store_fifo.queue\[5\]\[9\] lsu.store_fifo.queue\[6\]\[9\]
+ lsu.store_fifo.queue\[7\]\[9\] net411 net406 VGND VGND VPWR VPWR _1452_ sky130_fd_sc_hd__mux4_1
XFILLER_92_350 VGND VGND VPWR VPWR sky130_fd_sc_hd__decap_3
XTAP_TAPCELL_ROW_48_762 VGND VPWR sky130_fd_sc_hd__tapvpwrvgnd_1
XFILLER_37_277 VGND VGND VPWR VPWR sky130_fd_sc_hd__decap_3
X_4914_ clknet_leaf_83_clk _0969_ VGND VGND VPWR VPWR lsu.load_fifo.queue\[13\]\[9\]
+ sky130_fd_sc_hd__dfxtp_1
XFILLER_40_409 VGND VGND VPWR VPWR sky130_fd_sc_hd__fill_1
X_4845_ clknet_leaf_45_clk _0902_ _0095_ VGND VGND VPWR VPWR lsu.store_counter\[22\]
+ sky130_fd_sc_hd__dfrtp_1
X_4776_ clknet_leaf_44_clk _0833_ _0068_ VGND VGND VPWR VPWR net159 sky130_fd_sc_hd__dfrtp_1
X_3727_ acc.byte3\[1\] acc.byte2\[1\] VGND VGND VPWR VPWR _1209_ sky130_fd_sc_hd__or2_1
XFILLER_106_216 VGND VGND VPWR VPWR sky130_fd_sc_hd__decap_4
X_3658_ acc.byte1\[2\] acc.byte0\[2\] VGND VGND VPWR VPWR _1140_ sky130_fd_sc_hd__and2_1
X_3589_ net423 VGND VGND VPWR VPWR _0153_ sky130_fd_sc_hd__inv_2
X_2609_ net404 _1992_ VGND VGND VPWR VPWR _1993_ sky130_fd_sc_hd__nand2_1
XFILLER_0_505 VPWR VGND VPWR VGND sky130_ef_sc_hd__decap_12
XFILLER_0_538 VGND VGND VPWR VPWR sky130_fd_sc_hd__decap_4
XFILLER_102_444 VPWR VGND VPWR VGND sky130_ef_sc_hd__decap_12
XFILLER_57_15 VGND VGND VPWR VPWR sky130_fd_sc_hd__decap_8
XTAP_TAPCELL_ROW_89_1207 VGND VPWR sky130_fd_sc_hd__tapvpwrvgnd_1
XFILLER_56_531 VGND VGND VPWR VPWR sky130_fd_sc_hd__fill_1
XFILLER_43_214 VGND VGND VPWR VPWR sky130_fd_sc_hd__fill_2
XFILLER_73_69 VGND VGND VPWR VPWR sky130_fd_sc_hd__decap_3
XFILLER_71_578 VGND VGND VPWR VPWR sky130_fd_sc_hd__decap_4
XFILLER_12_601 VPWR VGND VPWR VGND sky130_ef_sc_hd__decap_12
XFILLER_24_461 VGND VGND VPWR VPWR sky130_fd_sc_hd__fill_1
XFILLER_98_77 VGND VGND VPWR VPWR sky130_fd_sc_hd__decap_6
XFILLER_93_125 VPWR VGND VPWR VGND sky130_ef_sc_hd__decap_12
Xfanout190 _2040_ VGND VGND VPWR VPWR net190 sky130_fd_sc_hd__clkbuf_4
XFILLER_93_169 VPWR VGND VPWR VGND sky130_ef_sc_hd__decap_12
XTAP_TAPCELL_ROW_17_412 VGND VPWR sky130_fd_sc_hd__tapvpwrvgnd_1
XTAP_TAPCELL_ROW_45_721 VGND VPWR sky130_fd_sc_hd__tapvpwrvgnd_1
XFILLER_15_461 VPWR VGND VPWR VGND sky130_ef_sc_hd__decap_12
X_2960_ net310 net909 net215 VGND VGND VPWR VPWR _0471_ sky130_fd_sc_hd__mux2_1
X_2891_ net676 net316 net193 VGND VGND VPWR VPWR _0402_ sky130_fd_sc_hd__mux2_1
X_4630_ clknet_leaf_3_clk _0687_ VGND VGND VPWR VPWR lsu.load_fifo.queue\[15\]\[14\]
+ sky130_fd_sc_hd__dfxtp_1
XFILLER_30_475 VGND VGND VPWR VPWR sky130_fd_sc_hd__fill_1
X_4561_ clknet_leaf_82_clk _0618_ VGND VGND VPWR VPWR lsu.load_fifo.queue\[0\]\[9\]
+ sky130_fd_sc_hd__dfxtp_1
Xhold605 lsu.load_fifo.queue\[7\]\[24\] VGND VGND VPWR VPWR net1073 sky130_fd_sc_hd__dlygate4sd3_1
X_3512_ net435 VGND VGND VPWR VPWR _0076_ sky130_fd_sc_hd__inv_2
Xhold616 lsu.store_fifo.queue\[2\]\[1\] VGND VGND VPWR VPWR net1084 sky130_fd_sc_hd__dlygate4sd3_1
Xhold627 lsu.store_fifo.queue\[7\]\[8\] VGND VGND VPWR VPWR net1095 sky130_fd_sc_hd__dlygate4sd3_1
X_4492_ clknet_leaf_5_clk _0549_ VGND VGND VPWR VPWR lsu.load_fifo.queue\[2\]\[4\]
+ sky130_fd_sc_hd__dfxtp_1
Xhold638 lsu.load_fifo.queue\[2\]\[23\] VGND VGND VPWR VPWR net1106 sky130_fd_sc_hd__dlygate4sd3_1
Xhold649 lsu.load_fifo.queue\[9\]\[22\] VGND VGND VPWR VPWR net1117 sky130_fd_sc_hd__dlygate4sd3_1
X_3443_ net430 VGND VGND VPWR VPWR _0007_ sky130_fd_sc_hd__inv_2
X_3374_ net309 net1217 net170 VGND VGND VPWR VPWR _0983_ sky130_fd_sc_hd__mux2_1
X_2325_ lsu.store_counter\[0\] net240 VGND VGND VPWR VPWR _1769_ sky130_fd_sc_hd__and2_1
X_2256_ net102 net268 VGND VGND VPWR VPWR _1721_ sky130_fd_sc_hd__nand2_4
XFILLER_27_18 VGND VGND VPWR VPWR sky130_fd_sc_hd__fill_1
XFILLER_72_309 VGND VGND VPWR VPWR sky130_fd_sc_hd__fill_2
X_2187_ lsu.load_counter\[21\] lsu.load_counter\[20\] _1676_ VGND VGND VPWR VPWR _1677_
+ sky130_fd_sc_hd__and3_1
XFILLER_38_586 VGND VGND VPWR VPWR sky130_fd_sc_hd__fill_2
XTAP_TAPCELL_ROW_84_1159 VGND VPWR sky130_fd_sc_hd__tapvpwrvgnd_1
XFILLER_25_225 VGND VGND VPWR VPWR sky130_fd_sc_hd__decap_6
XFILLER_53_567 VPWR VGND VPWR VGND sky130_ef_sc_hd__decap_12
X_4828_ clknet_leaf_36_clk _0885_ _0078_ VGND VGND VPWR VPWR lsu.store_counter\[5\]
+ sky130_fd_sc_hd__dfrtp_1
X_4759_ clknet_leaf_48_clk net1209 VGND VGND VPWR VPWR net144 sky130_fd_sc_hd__dfxtp_1
XFILLER_104_6 VPWR VGND VPWR VGND sky130_ef_sc_hd__decap_12
XTAP_TAPCELL_ROW_95_1277 VGND VPWR sky130_fd_sc_hd__tapvpwrvgnd_1
XFILLER_102_230 VGND VGND VPWR VPWR sky130_fd_sc_hd__fill_1
XTAP_TAPCELL_ROW_59_879 VGND VPWR sky130_fd_sc_hd__tapvpwrvgnd_1
XFILLER_44_512 VPWR VGND VPWR VGND sky130_ef_sc_hd__decap_12
XFILLER_17_73 VGND VGND VPWR VPWR sky130_fd_sc_hd__decap_3
XFILLER_44_545 VPWR VGND VPWR VGND sky130_ef_sc_hd__decap_12
XTAP_TAPCELL_ROW_104_1373 VGND VPWR sky130_fd_sc_hd__tapvpwrvgnd_1
XFILLER_71_386 VGND VGND VPWR VPWR sky130_fd_sc_hd__decap_6
XFILLER_12_475 VGND VGND VPWR VPWR sky130_fd_sc_hd__fill_1
XTAP_TAPCELL_ROW_22_470 VGND VPWR sky130_fd_sc_hd__tapvpwrvgnd_1
XFILLER_8_457 VPWR VGND VPWR VGND sky130_ef_sc_hd__decap_12
X_2110_ _1122_ _1123_ _1557_ _1121_ VGND VGND VPWR VPWR _1600_ sky130_fd_sc_hd__a31o_1
X_3090_ net321 net988 net186 VGND VGND VPWR VPWR _0594_ sky130_fd_sc_hd__mux2_1
XFILLER_54_309 VGND VGND VPWR VPWR sky130_fd_sc_hd__decap_6
XFILLER_94_489 VGND VGND VPWR VPWR sky130_fd_sc_hd__fill_1
XFILLER_47_350 VGND VGND VPWR VPWR sky130_fd_sc_hd__fill_1
X_3992_ _1431_ _1433_ _1430_ _1432_ net357 net361 VGND VGND VPWR VPWR _1434_ sky130_fd_sc_hd__mux4_1
X_2943_ net344 net1032 net216 VGND VGND VPWR VPWR _0454_ sky130_fd_sc_hd__mux2_1
X_2874_ net1010 net350 net195 VGND VGND VPWR VPWR _0385_ sky130_fd_sc_hd__mux2_1
X_4613_ clknet_leaf_27_clk _0670_ VGND VGND VPWR VPWR lsu.load_fifo.queue\[8\]\[29\]
+ sky130_fd_sc_hd__dfxtp_1
X_4544_ clknet_leaf_32_clk _0601_ VGND VGND VPWR VPWR lsu.load_fifo.queue\[1\]\[24\]
+ sky130_fd_sc_hd__dfxtp_1
Xhold402 lsu.load_fifo.queue\[4\]\[18\] VGND VGND VPWR VPWR net870 sky130_fd_sc_hd__dlygate4sd3_1
Xhold424 lsu.load_fifo.queue\[14\]\[5\] VGND VGND VPWR VPWR net892 sky130_fd_sc_hd__dlygate4sd3_1
Xhold413 lsu.store_fifo.queue\[0\]\[6\] VGND VGND VPWR VPWR net881 sky130_fd_sc_hd__dlygate4sd3_1
Xhold435 lsu.load_fifo.queue\[14\]\[8\] VGND VGND VPWR VPWR net903 sky130_fd_sc_hd__dlygate4sd3_1
XFILLER_104_539 VGND VGND VPWR VPWR sky130_fd_sc_hd__fill_2
Xhold457 _0831_ VGND VGND VPWR VPWR net925 sky130_fd_sc_hd__dlygate4sd3_1
Xhold468 lsu.load_fifo.queue\[3\]\[3\] VGND VGND VPWR VPWR net936 sky130_fd_sc_hd__dlygate4sd3_1
Xhold446 lsu.load_fifo.queue\[10\]\[18\] VGND VGND VPWR VPWR net914 sky130_fd_sc_hd__dlygate4sd3_1
X_4475_ clknet_leaf_8_clk _0532_ VGND VGND VPWR VPWR lsu.load_fifo.queue\[3\]\[19\]
+ sky130_fd_sc_hd__dfxtp_1
X_3426_ net273 net1116 _2058_ VGND VGND VPWR VPWR _1075_ sky130_fd_sc_hd__mux2_1
Xhold479 _0825_ VGND VGND VPWR VPWR net947 sky130_fd_sc_hd__dlygate4sd3_1
X_3357_ net342 net1028 net169 VGND VGND VPWR VPWR _0966_ sky130_fd_sc_hd__mux2_1
X_2308_ lsu.store_counter\[8\] _1721_ VGND VGND VPWR VPWR _1759_ sky130_fd_sc_hd__nor2_1
X_3288_ net348 net72 net248 VGND VGND VPWR VPWR _0850_ sky130_fd_sc_hd__mux2_1
X_5027_ clknet_leaf_55_clk _1082_ _0171_ VGND VGND VPWR VPWR acc.data_out\[6\] sky130_fd_sc_hd__dfrtp_1
X_2239_ net478 net480 _1708_ net243 VGND VGND VPWR VPWR _1709_ sky130_fd_sc_hd__o211ai_1
XFILLER_26_545 VGND VGND VPWR VPWR sky130_fd_sc_hd__decap_8
XFILLER_38_394 VGND VGND VPWR VPWR sky130_fd_sc_hd__decap_4
XFILLER_54_27 VGND VGND VPWR VPWR sky130_fd_sc_hd__fill_1
XTAP_TAPCELL_ROW_56_849 VGND VPWR sky130_fd_sc_hd__tapvpwrvgnd_1
XFILLER_26_589 VPWR VGND VPWR VGND sky130_ef_sc_hd__decap_12
XFILLER_80_194 VGND VGND VPWR VPWR sky130_fd_sc_hd__fill_2
XFILLER_21_250 VGND VGND VPWR VPWR sky130_fd_sc_hd__decap_6
XFILLER_5_405 VPWR VGND VPWR VGND sky130_ef_sc_hd__decap_12
XFILLER_5_449 VPWR VGND VPWR VGND sky130_ef_sc_hd__decap_12
XFILLER_79_57 VGND VGND VPWR VPWR sky130_fd_sc_hd__fill_1
XFILLER_103_561 VGND VGND VPWR VPWR sky130_fd_sc_hd__fill_2
XFILLER_36_309 VGND VGND VPWR VPWR sky130_fd_sc_hd__decap_6
XFILLER_48_158 VGND VGND VPWR VPWR sky130_fd_sc_hd__decap_3
XTAP_TAPCELL_ROW_106_1402 VGND VPWR sky130_fd_sc_hd__tapvpwrvgnd_1
XFILLER_76_489 VGND VGND VPWR VPWR sky130_fd_sc_hd__decap_4
XFILLER_28_94 VGND VGND VPWR VPWR sky130_fd_sc_hd__fill_2
XFILLER_44_353 VGND VGND VPWR VPWR sky130_fd_sc_hd__fill_1
XFILLER_8_276 VPWR VGND VPWR VGND sky130_ef_sc_hd__decap_12
X_2590_ lsu.current_load_addr\[5\] _1979_ net477 VGND VGND VPWR VPWR _0732_ sky130_fd_sc_hd__mux2_4
XFILLER_5_43 VGND VGND VPWR VPWR sky130_fd_sc_hd__fill_1
XFILLER_99_559 VGND VGND VPWR VPWR sky130_fd_sc_hd__fill_1
X_4260_ clknet_leaf_53_clk _0317_ VGND VGND VPWR VPWR lsu.store_fifo.queue\[1\]\[8\]
+ sky130_fd_sc_hd__dfxtp_1
XFILLER_86_209 VPWR VGND VPWR VGND sky130_ef_sc_hd__decap_12
X_4191_ clknet_leaf_66_clk _0248_ VGND VGND VPWR VPWR lsu.store_fifo.queue\[8\]\[9\]
+ sky130_fd_sc_hd__dfxtp_1
X_3211_ net280 net941 _2049_ VGND VGND VPWR VPWR _0722_ sky130_fd_sc_hd__mux2_1
X_3142_ net756 net349 net177 VGND VGND VPWR VPWR _0644_ sky130_fd_sc_hd__mux2_1
XFILLER_94_253 VPWR VGND VPWR VGND sky130_ef_sc_hd__decap_12
X_3073_ net355 net1002 net188 VGND VGND VPWR VPWR _0577_ sky130_fd_sc_hd__mux2_1
XPHY_EDGE_ROW_19_Left_126 VGND VGND VPWR VPWR sky130_fd_sc_hd__decap_3
XTAP_TAPCELL_ROW_53_808 VGND VPWR sky130_fd_sc_hd__tapvpwrvgnd_1
XTAP_TAPCELL_ROW_81_1118 VGND VPWR sky130_fd_sc_hd__tapvpwrvgnd_1
XFILLER_50_334 VGND VGND VPWR VPWR sky130_fd_sc_hd__fill_2
X_3975_ net1260 _1419_ net253 VGND VGND VPWR VPWR _1006_ sky130_fd_sc_hd__mux2_1
XFILLER_62_194 VGND VGND VPWR VPWR sky130_fd_sc_hd__fill_2
X_2926_ net963 net312 net220 VGND VGND VPWR VPWR _0438_ sky130_fd_sc_hd__mux2_1
XFILLER_50_389 VPWR VGND VPWR VGND sky130_ef_sc_hd__decap_12
XTAP_TAPCELL_ROW_61_896 VGND VPWR sky130_fd_sc_hd__tapvpwrvgnd_1
X_2857_ net627 net320 net223 VGND VGND VPWR VPWR _0368_ sky130_fd_sc_hd__mux2_1
XPHY_EDGE_ROW_28_Left_135 VGND VGND VPWR VPWR sky130_fd_sc_hd__decap_3
XTAP_TAPCELL_ROW_33_598 VGND VPWR sky130_fd_sc_hd__tapvpwrvgnd_1
X_2788_ net757 net282 _2031_ VGND VGND VPWR VPWR _0303_ sky130_fd_sc_hd__mux2_1
Xhold210 lsu.load_fifo.queue\[11\]\[7\] VGND VGND VPWR VPWR net678 sky130_fd_sc_hd__dlygate4sd3_1
Xhold232 _0828_ VGND VGND VPWR VPWR net700 sky130_fd_sc_hd__dlygate4sd3_1
Xhold243 lsu.load_fifo.queue\[0\]\[24\] VGND VGND VPWR VPWR net711 sky130_fd_sc_hd__dlygate4sd3_1
X_4527_ clknet_leaf_32_clk _0584_ VGND VGND VPWR VPWR lsu.load_fifo.queue\[1\]\[7\]
+ sky130_fd_sc_hd__dfxtp_1
Xhold221 lsu.load_fifo.queue\[15\]\[15\] VGND VGND VPWR VPWR net689 sky130_fd_sc_hd__dlygate4sd3_1
XTAP_TAPCELL_ROW_92_1247 VGND VPWR sky130_fd_sc_hd__tapvpwrvgnd_1
X_4458_ clknet_leaf_21_clk _0515_ VGND VGND VPWR VPWR lsu.load_fifo.queue\[3\]\[2\]
+ sky130_fd_sc_hd__dfxtp_1
Xhold254 lsu.load_fifo.queue\[12\]\[23\] VGND VGND VPWR VPWR net722 sky130_fd_sc_hd__dlygate4sd3_1
Xhold265 lsu.load_fifo.queue\[14\]\[27\] VGND VGND VPWR VPWR net733 sky130_fd_sc_hd__dlygate4sd3_1
Xhold287 lsu.load_fifo.queue\[6\]\[14\] VGND VGND VPWR VPWR net755 sky130_fd_sc_hd__dlygate4sd3_1
Xhold276 lsu.load_fifo.queue\[7\]\[7\] VGND VGND VPWR VPWR net744 sky130_fd_sc_hd__dlygate4sd3_1
X_3409_ net1076 net304 net199 VGND VGND VPWR VPWR _1059_ sky130_fd_sc_hd__mux2_1
XFILLER_49_38 VGND VGND VPWR VPWR sky130_fd_sc_hd__decap_4
Xhold298 lsu.load_fifo.queue\[5\]\[8\] VGND VGND VPWR VPWR net766 sky130_fd_sc_hd__dlygate4sd3_1
X_4389_ clknet_leaf_22_clk _0446_ VGND VGND VPWR VPWR lsu.load_fifo.queue\[6\]\[29\]
+ sky130_fd_sc_hd__dfxtp_1
XPHY_EDGE_ROW_37_Left_144 VGND VGND VPWR VPWR sky130_fd_sc_hd__decap_3
XFILLER_85_275 VGND VGND VPWR VPWR sky130_fd_sc_hd__fill_1
XTAP_TAPCELL_ROW_69_985 VGND VPWR sky130_fd_sc_hd__tapvpwrvgnd_1
XFILLER_18_309 VGND VGND VPWR VPWR sky130_fd_sc_hd__decap_4
XFILLER_46_629 VGND VGND VPWR VPWR sky130_fd_sc_hd__fill_1
XFILLER_85_297 VGND VGND VPWR VPWR sky130_fd_sc_hd__fill_2
XFILLER_41_301 VGND VGND VPWR VPWR sky130_fd_sc_hd__decap_6
XFILLER_53_183 VGND VGND VPWR VPWR sky130_fd_sc_hd__decap_8
XFILLER_41_356 VGND VGND VPWR VPWR sky130_fd_sc_hd__fill_1
XTAP_TAPCELL_ROW_101_1343 VGND VPWR sky130_fd_sc_hd__tapvpwrvgnd_1
XPHY_EDGE_ROW_46_Left_153 VGND VGND VPWR VPWR sky130_fd_sc_hd__decap_3
XFILLER_5_279 VGND VGND VPWR VPWR sky130_fd_sc_hd__fill_1
XFILLER_96_507 VGND VGND VPWR VPWR sky130_fd_sc_hd__fill_1
XFILLER_1_441 VGND VGND VPWR VPWR sky130_fd_sc_hd__decap_6
XPHY_EDGE_ROW_55_Left_162 VGND VGND VPWR VPWR sky130_fd_sc_hd__decap_3
XFILLER_1_485 VPWR VGND VPWR VGND sky130_ef_sc_hd__decap_12
XFILLER_103_391 VGND VGND VPWR VPWR sky130_fd_sc_hd__fill_1
XFILLER_39_93 VPWR VGND VPWR VGND sky130_ef_sc_hd__decap_12
XFILLER_49_445 VGND VGND VPWR VPWR sky130_fd_sc_hd__decap_3
XFILLER_76_253 VGND VGND VPWR VPWR sky130_fd_sc_hd__decap_4
XFILLER_37_629 VGND VGND VPWR VPWR sky130_fd_sc_hd__fill_1
XFILLER_91_223 VGND VGND VPWR VPWR sky130_fd_sc_hd__fill_1
XFILLER_64_437 VPWR VGND VPWR VGND sky130_ef_sc_hd__decap_12
XFILLER_55_70 VGND VGND VPWR VPWR sky130_fd_sc_hd__decap_6
XFILLER_44_183 VGND VGND VPWR VPWR sky130_fd_sc_hd__fill_1
XPHY_EDGE_ROW_64_Left_171 VGND VGND VPWR VPWR sky130_fd_sc_hd__decap_3
XFILLER_20_529 VGND VGND VPWR VPWR sky130_fd_sc_hd__decap_3
X_3760_ net281 _1237_ _1125_ VGND VGND VPWR VPWR _1081_ sky130_fd_sc_hd__mux2_1
XFILLER_9_541 VPWR VGND VPWR VGND sky130_ef_sc_hd__decap_12
X_2711_ net280 net1079 _2023_ VGND VGND VPWR VPWR _0234_ sky130_fd_sc_hd__mux2_1
XFILLER_9_585 VPWR VGND VPWR VGND sky130_ef_sc_hd__decap_12
XTAP_TAPCELL_ROW_30_557 VGND VPWR sky130_fd_sc_hd__tapvpwrvgnd_1
X_3691_ acc.byte3\[5\] acc.byte2\[5\] VGND VGND VPWR VPWR _1173_ sky130_fd_sc_hd__nand2_1
X_2642_ _2015_ _2016_ _2017_ VGND VGND VPWR VPWR _0708_ sky130_fd_sc_hd__nand3_1
XFILLER_65_3 VGND VGND VPWR VPWR sky130_fd_sc_hd__decap_6
X_2573_ lsu.current_load_addr\[8\] lsu.current_load_addr\[7\] _1923_ lsu.current_load_addr\[9\]
+ VGND VGND VPWR VPWR _1967_ sky130_fd_sc_hd__a31o_1
XFILLER_99_345 VPWR VGND VPWR VGND sky130_ef_sc_hd__decap_12
XTAP_TAPCELL_ROW_78_1091 VGND VPWR sky130_fd_sc_hd__tapvpwrvgnd_1
XPHY_EDGE_ROW_73_Left_180 VGND VGND VPWR VPWR sky130_fd_sc_hd__decap_3
X_4312_ clknet_leaf_1_clk _0369_ VGND VGND VPWR VPWR lsu.load_fifo.queue\[10\]\[18\]
+ sky130_fd_sc_hd__dfxtp_1
X_4243_ clknet_leaf_70_clk _0300_ VGND VGND VPWR VPWR lsu.store_fifo.queue\[2\]\[1\]
+ sky130_fd_sc_hd__dfxtp_1
XFILLER_87_529 VPWR VGND VPWR VGND sky130_ef_sc_hd__decap_12
XFILLER_95_551 VGND VGND VPWR VPWR sky130_fd_sc_hd__fill_2
X_4174_ clknet_leaf_61_clk _0231_ VGND VGND VPWR VPWR lsu.store_fifo.queue\[9\]\[2\]
+ sky130_fd_sc_hd__dfxtp_1
X_3125_ net674 net316 net181 VGND VGND VPWR VPWR _0628_ sky130_fd_sc_hd__mux2_1
X_3056_ net999 net322 net209 VGND VGND VPWR VPWR _0561_ sky130_fd_sc_hd__mux2_1
XTAP_TAPCELL_ROW_2_249 VGND VPWR sky130_fd_sc_hd__tapvpwrvgnd_1
XTAP_TAPCELL_ROW_38_646 VGND VPWR sky130_fd_sc_hd__tapvpwrvgnd_1
XTAP_TAPCELL_ROW_66_955 VGND VPWR sky130_fd_sc_hd__tapvpwrvgnd_1
XFILLER_70_418 VGND VGND VPWR VPWR sky130_fd_sc_hd__fill_2
XFILLER_63_470 VGND VGND VPWR VPWR sky130_fd_sc_hd__decap_4
XFILLER_11_529 VPWR VGND VPWR VGND sky130_ef_sc_hd__decap_12
X_3958_ lsu.load_fifo.queue\[0\]\[6\] lsu.load_fifo.queue\[1\]\[6\] lsu.load_fifo.queue\[2\]\[6\]
+ lsu.load_fifo.queue\[3\]\[6\] net383 net366 VGND VGND VPWR VPWR _1405_ sky130_fd_sc_hd__mux4_1
XFILLER_50_197 VGND VGND VPWR VPWR sky130_fd_sc_hd__fill_1
X_2909_ net900 net346 net220 VGND VGND VPWR VPWR _0421_ sky130_fd_sc_hd__mux2_1
X_3889_ net1283 _1345_ net256 VGND VGND VPWR VPWR _1018_ sky130_fd_sc_hd__mux2_1
XFILLER_105_612 VGND VGND VPWR VPWR sky130_fd_sc_hd__decap_4
XFILLER_19_629 VGND VGND VPWR VPWR sky130_fd_sc_hd__fill_1
XFILLER_33_109 VGND VGND VPWR VPWR sky130_fd_sc_hd__decap_3
XFILLER_26_172 VPWR VGND VPWR VGND sky130_ef_sc_hd__decap_12
XFILLER_41_197 VGND VGND VPWR VPWR sky130_fd_sc_hd__fill_1
XFILLER_6_533 VPWR VGND VPWR VGND sky130_ef_sc_hd__decap_12
XFILLER_69_529 VGND VGND VPWR VPWR sky130_fd_sc_hd__decap_8
XFILLER_77_573 VGND VGND VPWR VPWR sky130_fd_sc_hd__decap_6
XFILLER_2_77 VGND VGND VPWR VPWR sky130_fd_sc_hd__decap_6
XFILLER_92_587 VGND VGND VPWR VPWR sky130_fd_sc_hd__fill_1
XFILLER_17_150 VGND VGND VPWR VPWR sky130_fd_sc_hd__fill_1
X_4930_ clknet_leaf_68_clk _0985_ VGND VGND VPWR VPWR lsu.load_fifo.queue\[13\]\[25\]
+ sky130_fd_sc_hd__dfxtp_1
XFILLER_33_621 VGND VGND VPWR VPWR sky130_fd_sc_hd__fill_1
XTAP_TAPCELL_ROW_35_616 VGND VPWR sky130_fd_sc_hd__tapvpwrvgnd_1
XTAP_TAPCELL_ROW_63_925 VGND VPWR sky130_fd_sc_hd__tapvpwrvgnd_1
X_4861_ clknet_leaf_40_clk _0916_ _0111_ VGND VGND VPWR VPWR lsu.load_counter\[11\]
+ sky130_fd_sc_hd__dfrtp_1
X_3812_ lsu.load_fifo.queue\[0\]\[27\] lsu.load_fifo.queue\[1\]\[27\] lsu.load_fifo.queue\[2\]\[27\]
+ lsu.load_fifo.queue\[3\]\[27\] net387 net370 VGND VGND VPWR VPWR _1280_ sky130_fd_sc_hd__mux4_1
X_4792_ clknet_leaf_21_clk _0849_ VGND VGND VPWR VPWR lsu.load_fifo.data_in\[2\] sky130_fd_sc_hd__dfxtp_1
XTAP_TAPCELL_ROW_15_395 VGND VPWR sky130_fd_sc_hd__tapvpwrvgnd_1
XFILLER_20_326 VPWR VGND VPWR VGND sky130_ef_sc_hd__decap_12
XFILLER_32_197 VGND VGND VPWR VPWR sky130_fd_sc_hd__decap_3
X_3743_ _1196_ _1224_ VGND VGND VPWR VPWR _1225_ sky130_fd_sc_hd__nand2b_1
XFILLER_9_393 VPWR VGND VPWR VGND sky130_ef_sc_hd__decap_12
X_3674_ acc.byte3\[7\] acc.byte2\[7\] VGND VGND VPWR VPWR _1156_ sky130_fd_sc_hd__nand2_1
X_2625_ lsu.load_fifo.w_ptr\[1\] _1997_ VGND VGND VPWR VPWR _2003_ sky130_fd_sc_hd__nor2_2
Xoutput123 net123 VGND VGND VPWR VPWR load_addr[7] sky130_fd_sc_hd__buf_2
Xoutput112 net112 VGND VGND VPWR VPWR load_addr[17] sky130_fd_sc_hd__buf_2
Xoutput134 net134 VGND VGND VPWR VPWR store_addr[16] sky130_fd_sc_hd__buf_2
X_2556_ lsu.current_load_addr\[14\] _1954_ net161 VGND VGND VPWR VPWR _0741_ sky130_fd_sc_hd__mux2_4
Xoutput145 net145 VGND VGND VPWR VPWR store_addr[6] sky130_fd_sc_hd__buf_2
XTAP_TAPCELL_ROW_7_308 VGND VPWR sky130_fd_sc_hd__tapvpwrvgnd_1
Xoutput156 net156 VGND VGND VPWR VPWR store_data[7] sky130_fd_sc_hd__buf_2
X_2487_ net1307 _1903_ _1904_ net252 VGND VGND VPWR VPWR _0792_ sky130_fd_sc_hd__o22a_1
XFILLER_87_337 VPWR VGND VPWR VGND sky130_ef_sc_hd__decap_12
X_4226_ clknet_leaf_56_clk _0283_ VGND VGND VPWR VPWR lsu.store_fifo.queue\[4\]\[4\]
+ sky130_fd_sc_hd__dfxtp_1
X_4157_ clknet_leaf_68_clk _0214_ VGND VGND VPWR VPWR lsu.load_fifo.queue\[11\]\[17\]
+ sky130_fd_sc_hd__dfxtp_1
X_3108_ net513 net351 net183 VGND VGND VPWR VPWR _0611_ sky130_fd_sc_hd__mux2_1
XFILLER_55_223 VGND VGND VPWR VPWR sky130_fd_sc_hd__fill_1
X_4088_ net271 _1520_ VGND VGND VPWR VPWR _1521_ sky130_fd_sc_hd__nor2_1
X_3039_ _2034_ _2041_ VGND VGND VPWR VPWR _2043_ sky130_fd_sc_hd__and2_2
XFILLER_70_259 VGND VGND VPWR VPWR sky130_fd_sc_hd__fill_1
XFILLER_3_503 VGND VGND VPWR VPWR sky130_fd_sc_hd__fill_1
XFILLER_87_57 VGND VGND VPWR VPWR sky130_fd_sc_hd__decap_8
Xfanout350 lsu.load_fifo.data_in\[2\] VGND VGND VPWR VPWR net350 sky130_fd_sc_hd__clkbuf_2
XFILLER_93_329 VGND VGND VPWR VPWR sky130_fd_sc_hd__decap_6
Xfanout383 net386 VGND VGND VPWR VPWR net383 sky130_fd_sc_hd__buf_4
Xfanout361 net362 VGND VGND VPWR VPWR net361 sky130_fd_sc_hd__buf_4
Xfanout372 net373 VGND VGND VPWR VPWR net372 sky130_fd_sc_hd__clkbuf_4
Xfanout394 net399 VGND VGND VPWR VPWR net394 sky130_fd_sc_hd__clkbuf_4
XFILLER_46_245 VGND VGND VPWR VPWR sky130_fd_sc_hd__decap_6
XFILLER_74_598 VGND VGND VPWR VPWR sky130_fd_sc_hd__fill_1
XFILLER_74_587 VGND VGND VPWR VPWR sky130_fd_sc_hd__fill_1
XFILLER_36_61 VGND VGND VPWR VPWR sky130_fd_sc_hd__decap_6
XFILLER_61_259 VGND VGND VPWR VPWR sky130_fd_sc_hd__decap_3
XFILLER_14_197 VGND VGND VPWR VPWR sky130_fd_sc_hd__fill_2
Xinput36 load_base_addr[20] VGND VGND VPWR VPWR net36 sky130_fd_sc_hd__clkbuf_1
Xinput25 load_base_addr[10] VGND VGND VPWR VPWR net25 sky130_fd_sc_hd__clkbuf_1
Xinput14 count[20] VGND VGND VPWR VPWR net14 sky130_fd_sc_hd__buf_1
XTAP_TAPCELL_ROW_12_365 VGND VPWR sky130_fd_sc_hd__tapvpwrvgnd_1
XTAP_TAPCELL_ROW_40_674 VGND VPWR sky130_fd_sc_hd__tapvpwrvgnd_1
Xinput47 load_data[0] VGND VGND VPWR VPWR net47 sky130_fd_sc_hd__clkbuf_1
Xinput69 load_data[2] VGND VGND VPWR VPWR net69 sky130_fd_sc_hd__clkbuf_1
Xhold809 lsu.current_store_addr\[1\] VGND VGND VPWR VPWR net1277 sky130_fd_sc_hd__dlygate4sd3_1
Xinput58 load_data[1] VGND VGND VPWR VPWR net58 sky130_fd_sc_hd__clkbuf_1
X_2410_ lsu.current_store_addr\[6\] lsu.current_store_addr\[5\] lsu.current_store_addr\[4\]
+ _1842_ VGND VGND VPWR VPWR _1846_ sky130_fd_sc_hd__and4_1
XTAP_TAPCELL_ROW_75_1050 VGND VPWR sky130_fd_sc_hd__tapvpwrvgnd_1
X_3390_ net826 net342 net198 VGND VGND VPWR VPWR _1040_ sky130_fd_sc_hd__mux2_1
X_2341_ lsu.store_counter\[21\] _1572_ VGND VGND VPWR VPWR _1780_ sky130_fd_sc_hd__and2_1
X_2272_ net241 _1736_ VGND VGND VPWR VPWR _1737_ sky130_fd_sc_hd__nand2_1
XFILLER_69_337 VPWR VGND VPWR VGND sky130_ef_sc_hd__decap_12
XFILLER_84_307 VGND VGND VPWR VPWR sky130_fd_sc_hd__fill_1
X_4011_ net270 _1450_ VGND VGND VPWR VPWR _1451_ sky130_fd_sc_hd__nor2_1
XFILLER_28_3 VGND VGND VPWR VPWR sky130_fd_sc_hd__fill_2
XFILLER_96_189 VGND VGND VPWR VPWR sky130_fd_sc_hd__decap_6
XTAP_TAPCELL_ROW_48_763 VGND VPWR sky130_fd_sc_hd__tapvpwrvgnd_1
XFILLER_92_373 VGND VGND VPWR VPWR sky130_fd_sc_hd__fill_2
XFILLER_92_362 VGND VGND VPWR VPWR sky130_fd_sc_hd__fill_2
X_4913_ clknet_leaf_33_clk _0968_ VGND VGND VPWR VPWR lsu.load_fifo.queue\[13\]\[8\]
+ sky130_fd_sc_hd__dfxtp_1
X_4844_ clknet_leaf_45_clk _0901_ _0094_ VGND VGND VPWR VPWR lsu.store_counter\[21\]
+ sky130_fd_sc_hd__dfrtp_1
X_4775_ clknet_leaf_44_clk net927 VGND VGND VPWR VPWR net140 sky130_fd_sc_hd__dfxtp_1
X_3726_ _1142_ _1143_ VGND VGND VPWR VPWR _1208_ sky130_fd_sc_hd__xnor2_1
XFILLER_9_190 VGND VGND VPWR VPWR sky130_fd_sc_hd__decap_4
X_3657_ _1137_ _1138_ VGND VGND VPWR VPWR _1139_ sky130_fd_sc_hd__nand2_1
X_3588_ net422 VGND VGND VPWR VPWR _0152_ sky130_fd_sc_hd__inv_2
X_2608_ net410 net414 _1447_ VGND VGND VPWR VPWR _1992_ sky130_fd_sc_hd__and3_1
X_2539_ net33 net262 _1939_ _1941_ VGND VGND VPWR VPWR _1942_ sky130_fd_sc_hd__a22o_1
XFILLER_102_412 VGND VGND VPWR VPWR sky130_fd_sc_hd__decap_3
XFILLER_0_517 VPWR VGND VPWR VGND sky130_ef_sc_hd__decap_12
XFILLER_102_456 VGND VGND VPWR VPWR sky130_fd_sc_hd__decap_4
XTAP_TAPCELL_ROW_89_1208 VGND VPWR sky130_fd_sc_hd__tapvpwrvgnd_1
XFILLER_87_167 VGND VGND VPWR VPWR sky130_fd_sc_hd__fill_1
X_4209_ clknet_leaf_70_clk _0266_ VGND VGND VPWR VPWR lsu.store_fifo.queue\[6\]\[7\]
+ sky130_fd_sc_hd__dfxtp_1
XFILLER_83_373 VPWR VGND VPWR VGND sky130_ef_sc_hd__decap_12
XFILLER_16_407 VPWR VGND VPWR VGND sky130_ef_sc_hd__decap_12
XFILLER_12_613 VPWR VGND VPWR VGND sky130_ef_sc_hd__decap_12
XFILLER_78_101 VGND VGND VPWR VPWR sky130_fd_sc_hd__decap_4
XFILLER_93_137 VPWR VGND VPWR VGND sky130_ef_sc_hd__decap_12
Xfanout191 _2040_ VGND VGND VPWR VPWR net191 sky130_fd_sc_hd__buf_4
Xfanout180 _2046_ VGND VGND VPWR VPWR net180 sky130_fd_sc_hd__buf_2
XFILLER_74_373 VGND VGND VPWR VPWR sky130_fd_sc_hd__fill_1
XTAP_TAPCELL_ROW_17_413 VGND VPWR sky130_fd_sc_hd__tapvpwrvgnd_1
XFILLER_34_226 VGND VGND VPWR VPWR sky130_fd_sc_hd__fill_1
XTAP_TAPCELL_ROW_45_722 VGND VPWR sky130_fd_sc_hd__tapvpwrvgnd_1
XFILLER_62_568 VPWR VGND VPWR VGND sky130_ef_sc_hd__decap_12
XFILLER_15_473 VPWR VGND VPWR VGND sky130_ef_sc_hd__decap_12
X_2890_ net1083 net318 net193 VGND VGND VPWR VPWR _0401_ sky130_fd_sc_hd__mux2_1
X_4560_ clknet_leaf_54_clk _0617_ VGND VGND VPWR VPWR lsu.load_fifo.queue\[0\]\[8\]
+ sky130_fd_sc_hd__dfxtp_1
X_3511_ net435 VGND VGND VPWR VPWR _0075_ sky130_fd_sc_hd__inv_2
Xhold606 lsu.load_fifo.queue\[13\]\[9\] VGND VGND VPWR VPWR net1074 sky130_fd_sc_hd__dlygate4sd3_1
X_4491_ clknet_leaf_87_clk _0548_ VGND VGND VPWR VPWR lsu.load_fifo.queue\[2\]\[3\]
+ sky130_fd_sc_hd__dfxtp_1
Xhold617 lsu.store_fifo.queue\[11\]\[1\] VGND VGND VPWR VPWR net1085 sky130_fd_sc_hd__dlygate4sd3_1
Xhold628 lsu.load_fifo.queue\[13\]\[16\] VGND VGND VPWR VPWR net1096 sky130_fd_sc_hd__dlygate4sd3_1
XFILLER_6_182 VPWR VGND VPWR VGND sky130_ef_sc_hd__decap_12
Xhold639 lsu.load_fifo.queue\[14\]\[14\] VGND VGND VPWR VPWR net1107 sky130_fd_sc_hd__dlygate4sd3_1
X_3442_ net430 VGND VGND VPWR VPWR _0006_ sky130_fd_sc_hd__inv_2
X_3373_ net310 net1232 net170 VGND VGND VPWR VPWR _0982_ sky130_fd_sc_hd__mux2_1
X_2324_ _1768_ _1767_ lsu.store_counter\[2\] VGND VGND VPWR VPWR _0882_ sky130_fd_sc_hd__mux2_1
XFILLER_97_498 VGND VGND VPWR VPWR sky130_fd_sc_hd__decap_6
XFILLER_97_487 VGND VGND VPWR VPWR sky130_fd_sc_hd__decap_4
X_2255_ lsu.storer_state\[2\] net102 _1713_ VGND VGND VPWR VPWR _1720_ sky130_fd_sc_hd__and3_2
X_2186_ lsu.load_counter\[19\] lsu.load_counter\[18\] _1675_ VGND VGND VPWR VPWR _1676_
+ sky130_fd_sc_hd__and3_1
XTAP_TAPCELL_ROW_84_1149 VGND VPWR sky130_fd_sc_hd__tapvpwrvgnd_1
XFILLER_80_343 VGND VGND VPWR VPWR sky130_fd_sc_hd__fill_1
XFILLER_53_579 VGND VGND VPWR VPWR sky130_fd_sc_hd__fill_2
X_4827_ clknet_leaf_36_clk _0884_ _0077_ VGND VGND VPWR VPWR lsu.store_counter\[4\]
+ sky130_fd_sc_hd__dfrtp_1
XFILLER_5_609 VGND VGND VPWR VPWR sky130_fd_sc_hd__decap_6
X_4758_ clknet_leaf_48_clk _0815_ VGND VGND VPWR VPWR net143 sky130_fd_sc_hd__dfxtp_1
X_4689_ clknet_leaf_38_clk _0746_ _0035_ VGND VGND VPWR VPWR lsu.current_load_addr\[19\]
+ sky130_fd_sc_hd__dfrtp_2
X_3709_ acc.byte3\[3\] acc.byte2\[3\] VGND VGND VPWR VPWR _1191_ sky130_fd_sc_hd__nand2_1
XTAP_TAPCELL_ROW_95_1278 VGND VPWR sky130_fd_sc_hd__tapvpwrvgnd_1
XFILLER_88_421 VGND VGND VPWR VPWR sky130_fd_sc_hd__decap_8
XFILLER_102_253 VGND VGND VPWR VPWR sky130_fd_sc_hd__fill_2
XFILLER_48_329 VPWR VGND VPWR VGND sky130_ef_sc_hd__decap_12
XFILLER_44_524 VGND VGND VPWR VPWR sky130_fd_sc_hd__decap_8
XFILLER_16_226 VGND VGND VPWR VPWR sky130_fd_sc_hd__decap_6
XFILLER_44_557 VGND VGND VPWR VPWR sky130_fd_sc_hd__decap_8
XFILLER_31_207 VGND VGND VPWR VPWR sky130_fd_sc_hd__decap_6
XTAP_TAPCELL_ROW_104_1374 VGND VPWR sky130_fd_sc_hd__tapvpwrvgnd_1
XFILLER_71_398 VPWR VGND VPWR VGND sky130_ef_sc_hd__decap_12
XFILLER_12_421 VPWR VGND VPWR VGND sky130_ef_sc_hd__decap_12
XFILLER_8_403 VPWR VGND VPWR VGND sky130_ef_sc_hd__decap_12
XFILLER_33_73 VGND VGND VPWR VPWR sky130_fd_sc_hd__fill_1
XFILLER_8_469 VGND VGND VPWR VPWR sky130_fd_sc_hd__decap_6
XTAP_TAPCELL_ROW_22_471 VGND VPWR sky130_fd_sc_hd__tapvpwrvgnd_1
XTAP_TAPCELL_ROW_50_780 VGND VPWR sky130_fd_sc_hd__tapvpwrvgnd_1
XFILLER_106_581 VGND VGND VPWR VPWR sky130_fd_sc_hd__decap_6
XTAP_TAPCELL_ROW_72_1020 VGND VPWR sky130_fd_sc_hd__tapvpwrvgnd_1
XFILLER_94_413 VGND VGND VPWR VPWR sky130_fd_sc_hd__decap_6
XFILLER_74_91 VGND VGND VPWR VPWR sky130_fd_sc_hd__fill_1
X_3991_ lsu.load_fifo.queue\[8\]\[1\] lsu.load_fifo.queue\[9\]\[1\] lsu.load_fifo.queue\[10\]\[1\]
+ lsu.load_fifo.queue\[11\]\[1\] net389 net372 VGND VGND VPWR VPWR _1433_ sky130_fd_sc_hd__mux4_1
XFILLER_95_3 VPWR VGND VPWR VGND sky130_ef_sc_hd__decap_12
XFILLER_50_549 VGND VGND VPWR VPWR sky130_fd_sc_hd__fill_1
X_2942_ net346 net937 net216 VGND VGND VPWR VPWR _0453_ sky130_fd_sc_hd__mux2_1
X_2873_ net651 net353 net193 VGND VGND VPWR VPWR _0384_ sky130_fd_sc_hd__mux2_1
XFILLER_30_295 VGND VGND VPWR VPWR sky130_fd_sc_hd__decap_4
X_4612_ clknet_leaf_13_clk _0669_ VGND VGND VPWR VPWR lsu.load_fifo.queue\[8\]\[28\]
+ sky130_fd_sc_hd__dfxtp_1
X_4543_ clknet_leaf_81_clk _0600_ VGND VGND VPWR VPWR lsu.load_fifo.queue\[1\]\[23\]
+ sky130_fd_sc_hd__dfxtp_1
Xhold403 lsu.load_fifo.queue\[15\]\[20\] VGND VGND VPWR VPWR net871 sky130_fd_sc_hd__dlygate4sd3_1
Xhold425 lsu.load_fifo.queue\[7\]\[9\] VGND VGND VPWR VPWR net893 sky130_fd_sc_hd__dlygate4sd3_1
Xhold414 lsu.store_fifo.queue\[15\]\[2\] VGND VGND VPWR VPWR net882 sky130_fd_sc_hd__dlygate4sd3_1
Xhold436 lsu.store_fifo.queue\[15\]\[6\] VGND VGND VPWR VPWR net904 sky130_fd_sc_hd__dlygate4sd3_1
Xhold458 net140 VGND VGND VPWR VPWR net926 sky130_fd_sc_hd__dlygate4sd3_1
X_4474_ clknet_leaf_8_clk _0531_ VGND VGND VPWR VPWR lsu.load_fifo.queue\[3\]\[18\]
+ sky130_fd_sc_hd__dfxtp_1
Xhold469 lsu.load_fifo.queue\[5\]\[4\] VGND VGND VPWR VPWR net937 sky130_fd_sc_hd__dlygate4sd3_1
Xhold447 lsu.load_fifo.queue\[6\]\[0\] VGND VGND VPWR VPWR net915 sky130_fd_sc_hd__dlygate4sd3_1
X_3425_ net275 net779 _2058_ VGND VGND VPWR VPWR _1074_ sky130_fd_sc_hd__mux2_1
X_3356_ net344 net866 net169 VGND VGND VPWR VPWR _0965_ sky130_fd_sc_hd__mux2_1
XFILLER_85_413 VGND VGND VPWR VPWR sky130_fd_sc_hd__decap_4
X_2307_ net266 _1728_ net239 VGND VGND VPWR VPWR _1758_ sky130_fd_sc_hd__o21ai_1
X_3287_ net350 net69 net250 VGND VGND VPWR VPWR _0849_ sky130_fd_sc_hd__mux2_1
X_2238_ lsu.load_counter\[1\] lsu.load_counter\[0\] net263 VGND VGND VPWR VPWR _1708_
+ sky130_fd_sc_hd__a21o_1
X_5026_ clknet_leaf_72_clk _1081_ _0170_ VGND VGND VPWR VPWR acc.data_out\[5\] sky130_fd_sc_hd__dfrtp_1
XFILLER_38_373 VGND VGND VPWR VPWR sky130_fd_sc_hd__fill_1
X_2169_ _1584_ _1616_ net235 _1658_ _1655_ VGND VGND VPWR VPWR _1659_ sky130_fd_sc_hd__a41o_1
XFILLER_65_181 VGND VGND VPWR VPWR sky130_fd_sc_hd__fill_1
XFILLER_5_417 VPWR VGND VPWR VGND sky130_ef_sc_hd__decap_12
XFILLER_103_540 VGND VGND VPWR VPWR sky130_fd_sc_hd__fill_2
XFILLER_95_57 VPWR VGND VPWR VGND sky130_ef_sc_hd__decap_12
XFILLER_0_166 VGND VGND VPWR VPWR sky130_fd_sc_hd__fill_2
XFILLER_91_405 VGND VGND VPWR VPWR sky130_fd_sc_hd__fill_1
XTAP_TAPCELL_ROW_106_1403 VGND VPWR sky130_fd_sc_hd__tapvpwrvgnd_1
XFILLER_91_449 VGND VGND VPWR VPWR sky130_fd_sc_hd__fill_1
Xclkbuf_leaf_83_clk clknet_3_1__leaf_clk VGND VGND VPWR VPWR clknet_leaf_83_clk sky130_fd_sc_hd__clkbuf_8
XFILLER_44_321 VPWR VGND VPWR VGND sky130_ef_sc_hd__decap_12
XTAP_TAPCELL_ROW_27_530 VGND VPWR sky130_fd_sc_hd__tapvpwrvgnd_1
XFILLER_44_365 VGND VGND VPWR VPWR sky130_fd_sc_hd__fill_1
XFILLER_44_83 VGND VGND VPWR VPWR sky130_fd_sc_hd__fill_1
XFILLER_8_233 VGND VGND VPWR VPWR sky130_fd_sc_hd__decap_3
XFILLER_8_288 VGND VGND VPWR VPWR sky130_fd_sc_hd__decap_4
XFILLER_8_266 VGND VGND VPWR VPWR sky130_fd_sc_hd__fill_1
XFILLER_69_91 VGND VGND VPWR VPWR sky130_fd_sc_hd__fill_1
X_4190_ clknet_leaf_60_clk _0247_ VGND VGND VPWR VPWR lsu.store_fifo.queue\[8\]\[8\]
+ sky130_fd_sc_hd__dfxtp_1
X_3210_ net283 net1173 _2049_ VGND VGND VPWR VPWR _0721_ sky130_fd_sc_hd__mux2_1
X_3141_ net510 net351 net179 VGND VGND VPWR VPWR _0643_ sky130_fd_sc_hd__mux2_1
XFILLER_94_221 VPWR VGND VPWR VGND sky130_ef_sc_hd__decap_12
XFILLER_10_3 VGND VGND VPWR VPWR sky130_fd_sc_hd__fill_2
XFILLER_94_265 VPWR VGND VPWR VGND sky130_ef_sc_hd__decap_12
X_3072_ _2003_ _2041_ VGND VGND VPWR VPWR _2044_ sky130_fd_sc_hd__nand2_4
Xclkbuf_leaf_74_clk clknet_3_1__leaf_clk VGND VGND VPWR VPWR clknet_leaf_74_clk sky130_fd_sc_hd__clkbuf_8
XTAP_TAPCELL_ROW_53_809 VGND VPWR sky130_fd_sc_hd__tapvpwrvgnd_1
XTAP_TAPCELL_ROW_81_1119 VGND VPWR sky130_fd_sc_hd__tapvpwrvgnd_1
X_3974_ _1415_ _1418_ net358 VGND VGND VPWR VPWR _1419_ sky130_fd_sc_hd__mux2_1
X_2925_ net687 net314 net218 VGND VGND VPWR VPWR _0437_ sky130_fd_sc_hd__mux2_1
XTAP_TAPCELL_ROW_33_588 VGND VPWR sky130_fd_sc_hd__tapvpwrvgnd_1
XTAP_TAPCELL_ROW_61_897 VGND VPWR sky130_fd_sc_hd__tapvpwrvgnd_1
X_2856_ net632 net323 net225 VGND VGND VPWR VPWR _0367_ sky130_fd_sc_hd__mux2_1
XFILLER_31_593 VGND VGND VPWR VPWR sky130_fd_sc_hd__decap_8
Xhold211 lsu.load_fifo.queue\[11\]\[2\] VGND VGND VPWR VPWR net679 sky130_fd_sc_hd__dlygate4sd3_1
X_2787_ net868 net284 _2031_ VGND VGND VPWR VPWR _0302_ sky130_fd_sc_hd__mux2_1
Xhold200 lsu.store_fifo.queue\[15\]\[7\] VGND VGND VPWR VPWR net668 sky130_fd_sc_hd__dlygate4sd3_1
Xhold244 lsu.load_fifo.queue\[12\]\[27\] VGND VGND VPWR VPWR net712 sky130_fd_sc_hd__dlygate4sd3_1
Xhold222 lsu.load_fifo.queue\[15\]\[3\] VGND VGND VPWR VPWR net690 sky130_fd_sc_hd__dlygate4sd3_1
Xhold233 lsu.load_fifo.queue\[3\]\[11\] VGND VGND VPWR VPWR net701 sky130_fd_sc_hd__dlygate4sd3_1
X_4526_ clknet_leaf_1_clk _0583_ VGND VGND VPWR VPWR lsu.load_fifo.queue\[1\]\[6\]
+ sky130_fd_sc_hd__dfxtp_1
XTAP_TAPCELL_ROW_92_1237 VGND VPWR sky130_fd_sc_hd__tapvpwrvgnd_1
Xhold255 lsu.load_fifo.queue\[9\]\[12\] VGND VGND VPWR VPWR net723 sky130_fd_sc_hd__dlygate4sd3_1
Xhold277 lsu.load_fifo.queue\[3\]\[31\] VGND VGND VPWR VPWR net745 sky130_fd_sc_hd__dlygate4sd3_1
X_4457_ clknet_leaf_77_clk _0514_ VGND VGND VPWR VPWR lsu.load_fifo.queue\[3\]\[1\]
+ sky130_fd_sc_hd__dfxtp_1
Xhold266 lsu.load_fifo.queue\[10\]\[5\] VGND VGND VPWR VPWR net734 sky130_fd_sc_hd__dlygate4sd3_1
X_3408_ net894 net306 net201 VGND VGND VPWR VPWR _1058_ sky130_fd_sc_hd__mux2_1
Xhold288 lsu.load_fifo.queue\[8\]\[3\] VGND VGND VPWR VPWR net756 sky130_fd_sc_hd__dlygate4sd3_1
Xhold299 lsu.load_fifo.queue\[11\]\[26\] VGND VGND VPWR VPWR net767 sky130_fd_sc_hd__dlygate4sd3_1
X_4388_ clknet_leaf_16_clk _0445_ VGND VGND VPWR VPWR lsu.load_fifo.queue\[6\]\[28\]
+ sky130_fd_sc_hd__dfxtp_1
X_3339_ net952 net313 net175 VGND VGND VPWR VPWR _0949_ sky130_fd_sc_hd__mux2_1
XFILLER_100_576 VPWR VGND VPWR VGND sky130_ef_sc_hd__decap_12
XTAP_TAPCELL_ROW_69_986 VGND VPWR sky130_fd_sc_hd__tapvpwrvgnd_1
XFILLER_73_449 VPWR VGND VPWR VGND sky130_ef_sc_hd__decap_12
Xclkbuf_leaf_65_clk clknet_3_5__leaf_clk VGND VGND VPWR VPWR clknet_leaf_65_clk sky130_fd_sc_hd__clkbuf_8
X_5009_ clknet_leaf_13_clk _1064_ VGND VGND VPWR VPWR lsu.load_fifo.queue\[14\]\[30\]
+ sky130_fd_sc_hd__dfxtp_1
XFILLER_81_15 VGND VGND VPWR VPWR sky130_fd_sc_hd__decap_8
XTAP_TAPCELL_ROW_101_1344 VGND VPWR sky130_fd_sc_hd__tapvpwrvgnd_1
XFILLER_30_85 VGND VGND VPWR VPWR sky130_fd_sc_hd__decap_6
XFILLER_76_243 VGND VGND VPWR VPWR sky130_fd_sc_hd__decap_8
XFILLER_1_497 VGND VGND VPWR VPWR sky130_fd_sc_hd__decap_6
XPHY_EDGE_ROW_101_Right_101 VGND VGND VPWR VPWR sky130_fd_sc_hd__decap_3
Xclkbuf_leaf_56_clk clknet_3_4__leaf_clk VGND VGND VPWR VPWR clknet_leaf_56_clk sky130_fd_sc_hd__clkbuf_8
XFILLER_64_449 VGND VGND VPWR VPWR sky130_fd_sc_hd__decap_8
XFILLER_91_279 VGND VGND VPWR VPWR sky130_fd_sc_hd__fill_1
XFILLER_60_600 VGND VGND VPWR VPWR sky130_fd_sc_hd__fill_2
XFILLER_9_553 VGND VGND VPWR VPWR sky130_fd_sc_hd__decap_6
X_2710_ net283 net1151 _2023_ VGND VGND VPWR VPWR _0233_ sky130_fd_sc_hd__mux2_1
XTAP_TAPCELL_ROW_30_558 VGND VPWR sky130_fd_sc_hd__tapvpwrvgnd_1
X_3690_ _1167_ _1168_ VGND VGND VPWR VPWR _1172_ sky130_fd_sc_hd__xor2_1
XFILLER_9_597 VPWR VGND VPWR VGND sky130_ef_sc_hd__decap_12
X_2641_ lsu.store_fifo.w_ptr\[3\] _2013_ VGND VGND VPWR VPWR _2017_ sky130_fd_sc_hd__nand2_1
X_2572_ lsu.current_load_addr\[10\] _1966_ _1666_ VGND VGND VPWR VPWR _0737_ sky130_fd_sc_hd__mux2_2
XFILLER_58_3 VGND VGND VPWR VPWR sky130_fd_sc_hd__decap_8
XTAP_TAPCELL_ROW_78_1092 VGND VPWR sky130_fd_sc_hd__tapvpwrvgnd_1
X_4311_ clknet_leaf_69_clk _0368_ VGND VGND VPWR VPWR lsu.load_fifo.queue\[10\]\[17\]
+ sky130_fd_sc_hd__dfxtp_1
XFILLER_99_357 VPWR VGND VPWR VGND sky130_ef_sc_hd__decap_12
X_4242_ clknet_leaf_53_clk _0299_ VGND VGND VPWR VPWR lsu.store_fifo.queue\[2\]\[0\]
+ sky130_fd_sc_hd__dfxtp_1
X_4173_ clknet_leaf_64_clk _0230_ VGND VGND VPWR VPWR lsu.store_fifo.queue\[9\]\[1\]
+ sky130_fd_sc_hd__dfxtp_1
X_3124_ net853 net318 net181 VGND VGND VPWR VPWR _0627_ sky130_fd_sc_hd__mux2_1
X_3055_ net1050 net325 net209 VGND VGND VPWR VPWR _0560_ sky130_fd_sc_hd__mux2_1
XFILLER_55_449 VGND VGND VPWR VPWR sky130_fd_sc_hd__fill_1
Xclkbuf_leaf_47_clk clknet_3_7__leaf_clk VGND VGND VPWR VPWR clknet_leaf_47_clk sky130_fd_sc_hd__clkbuf_8
XTAP_TAPCELL_ROW_38_647 VGND VPWR sky130_fd_sc_hd__tapvpwrvgnd_1
XTAP_TAPCELL_ROW_66_956 VGND VPWR sky130_fd_sc_hd__tapvpwrvgnd_1
X_3957_ lsu.load_fifo.queue\[4\]\[6\] lsu.load_fifo.queue\[5\]\[6\] lsu.load_fifo.queue\[6\]\[6\]
+ lsu.load_fifo.queue\[7\]\[6\] net383 net366 VGND VGND VPWR VPWR _1404_ sky130_fd_sc_hd__mux4_1
X_2908_ net1019 net348 net218 VGND VGND VPWR VPWR _0420_ sky130_fd_sc_hd__mux2_1
X_3888_ _1342_ _1344_ _1341_ _1343_ net359 net365 VGND VGND VPWR VPWR _1345_ sky130_fd_sc_hd__mux4_1
X_2839_ net418 _2034_ net416 VGND VGND VPWR VPWR _2035_ sky130_fd_sc_hd__and3b_2
XFILLER_104_101 VGND VGND VPWR VPWR sky130_fd_sc_hd__fill_2
X_4509_ clknet_leaf_14_clk _0566_ VGND VGND VPWR VPWR lsu.load_fifo.queue\[2\]\[21\]
+ sky130_fd_sc_hd__dfxtp_1
XFILLER_104_123 VGND VGND VPWR VPWR sky130_fd_sc_hd__fill_1
XFILLER_86_530 VGND VGND VPWR VPWR sky130_fd_sc_hd__fill_2
XFILLER_46_438 VGND VGND VPWR VPWR sky130_fd_sc_hd__fill_1
Xclkbuf_leaf_38_clk clknet_3_6__leaf_clk VGND VGND VPWR VPWR clknet_leaf_38_clk sky130_fd_sc_hd__clkbuf_8
XFILLER_73_246 VGND VGND VPWR VPWR sky130_fd_sc_hd__decap_4
XPHY_EDGE_ROW_1_Left_108 VGND VGND VPWR VPWR sky130_fd_sc_hd__decap_3
XFILLER_26_184 VGND VGND VPWR VPWR sky130_fd_sc_hd__decap_4
XFILLER_6_501 VPWR VGND VPWR VGND sky130_ef_sc_hd__decap_12
XFILLER_6_545 VPWR VGND VPWR VGND sky130_ef_sc_hd__decap_12
XFILLER_41_95 VPWR VGND VPWR VGND sky130_ef_sc_hd__decap_12
XFILLER_6_589 VPWR VGND VPWR VGND sky130_ef_sc_hd__decap_12
XFILLER_92_533 VGND VGND VPWR VPWR sky130_fd_sc_hd__fill_1
XFILLER_92_511 VGND VGND VPWR VPWR sky130_fd_sc_hd__fill_2
XFILLER_49_276 VGND VGND VPWR VPWR sky130_fd_sc_hd__decap_4
Xclkbuf_leaf_29_clk clknet_3_3__leaf_clk VGND VGND VPWR VPWR clknet_leaf_29_clk sky130_fd_sc_hd__clkbuf_8
XFILLER_92_555 VGND VGND VPWR VPWR sky130_fd_sc_hd__fill_1
XTAP_TAPCELL_ROW_35_617 VGND VPWR sky130_fd_sc_hd__tapvpwrvgnd_1
XFILLER_52_419 VGND VGND VPWR VPWR sky130_fd_sc_hd__fill_1
XTAP_TAPCELL_ROW_63_926 VGND VPWR sky130_fd_sc_hd__tapvpwrvgnd_1
X_4860_ clknet_leaf_39_clk _0915_ _0110_ VGND VGND VPWR VPWR lsu.load_counter\[10\]
+ sky130_fd_sc_hd__dfrtp_1
XFILLER_17_184 VPWR VGND VPWR VGND sky130_ef_sc_hd__decap_12
X_3811_ lsu.load_fifo.queue\[4\]\[27\] lsu.load_fifo.queue\[5\]\[27\] lsu.load_fifo.queue\[6\]\[27\]
+ lsu.load_fifo.queue\[7\]\[27\] net387 net370 VGND VGND VPWR VPWR _1279_ sky130_fd_sc_hd__mux4_1
XFILLER_60_452 VGND VGND VPWR VPWR sky130_fd_sc_hd__decap_6
XFILLER_60_474 VGND VGND VPWR VPWR sky130_fd_sc_hd__fill_2
X_4791_ clknet_leaf_82_clk _0848_ VGND VGND VPWR VPWR lsu.load_fifo.data_in\[1\] sky130_fd_sc_hd__dfxtp_1
XFILLER_20_338 VGND VGND VPWR VPWR sky130_fd_sc_hd__decap_8
XFILLER_32_176 VGND VGND VPWR VPWR sky130_fd_sc_hd__decap_4
XTAP_TAPCELL_ROW_15_396 VGND VPWR sky130_fd_sc_hd__tapvpwrvgnd_1
X_3742_ _1190_ _1195_ VGND VGND VPWR VPWR _1224_ sky130_fd_sc_hd__nand2_1
X_3673_ _1128_ _1154_ _1127_ VGND VGND VPWR VPWR _1155_ sky130_fd_sc_hd__a21oi_1
X_2624_ _1999_ _2002_ VGND VGND VPWR VPWR _0711_ sky130_fd_sc_hd__and2_1
Xoutput124 net124 VGND VGND VPWR VPWR load_addr[8] sky130_fd_sc_hd__buf_2
Xoutput113 net113 VGND VGND VPWR VPWR load_addr[18] sky130_fd_sc_hd__buf_2
X_2555_ net29 net259 _1952_ _1953_ VGND VGND VPWR VPWR _1954_ sky130_fd_sc_hd__a22o_1
XFILLER_99_121 VGND VGND VPWR VPWR sky130_fd_sc_hd__fill_2
Xoutput135 net135 VGND VGND VPWR VPWR store_addr[17] sky130_fd_sc_hd__buf_2
Xoutput146 net146 VGND VGND VPWR VPWR store_addr[7] sky130_fd_sc_hd__buf_2
XTAP_TAPCELL_ROW_7_309 VGND VPWR sky130_fd_sc_hd__tapvpwrvgnd_1
Xoutput157 net157 VGND VGND VPWR VPWR store_data[8] sky130_fd_sc_hd__buf_2
X_2486_ net95 _1843_ net269 VGND VGND VPWR VPWR _1904_ sky130_fd_sc_hd__mux2_1
XFILLER_87_349 VPWR VGND VPWR VGND sky130_ef_sc_hd__decap_12
X_4225_ clknet_leaf_70_clk _0282_ VGND VGND VPWR VPWR lsu.store_fifo.queue\[4\]\[3\]
+ sky130_fd_sc_hd__dfxtp_1
X_4156_ clknet_leaf_31_clk _0213_ VGND VGND VPWR VPWR lsu.load_fifo.queue\[11\]\[16\]
+ sky130_fd_sc_hd__dfxtp_1
XFILLER_95_393 VGND VGND VPWR VPWR sky130_fd_sc_hd__decap_6
X_3107_ net600 net352 net181 VGND VGND VPWR VPWR _0610_ sky130_fd_sc_hd__mux2_1
XFILLER_46_29 VGND VGND VPWR VPWR sky130_fd_sc_hd__decap_3
X_4087_ lsu.store_fifo.queue\[8\]\[2\] lsu.store_fifo.queue\[9\]\[2\] lsu.store_fifo.queue\[10\]\[2\]
+ lsu.store_fifo.queue\[11\]\[2\] net412 net407 VGND VGND VPWR VPWR _1520_ sky130_fd_sc_hd__mux4_1
X_3038_ net745 net292 net211 VGND VGND VPWR VPWR _0544_ sky130_fd_sc_hd__mux2_1
X_4989_ clknet_leaf_24_clk _1044_ VGND VGND VPWR VPWR lsu.load_fifo.queue\[14\]\[10\]
+ sky130_fd_sc_hd__dfxtp_1
XFILLER_3_559 VGND VGND VPWR VPWR sky130_fd_sc_hd__fill_1
Xfanout340 lsu.load_fifo.data_in\[7\] VGND VGND VPWR VPWR net340 sky130_fd_sc_hd__clkbuf_2
Xfanout351 lsu.load_fifo.data_in\[2\] VGND VGND VPWR VPWR net351 sky130_fd_sc_hd__dlymetal6s2s_1
Xfanout384 net386 VGND VGND VPWR VPWR net384 sky130_fd_sc_hd__clkbuf_4
Xfanout362 net365 VGND VGND VPWR VPWR net362 sky130_fd_sc_hd__clkbuf_4
Xfanout373 net382 VGND VGND VPWR VPWR net373 sky130_fd_sc_hd__buf_2
XPHY_EDGE_ROW_92_Left_199 VGND VGND VPWR VPWR sky130_fd_sc_hd__decap_3
Xfanout395 net398 VGND VGND VPWR VPWR net395 sky130_fd_sc_hd__clkbuf_4
XFILLER_19_449 VPWR VGND VPWR VGND sky130_ef_sc_hd__decap_12
XFILLER_34_419 VGND VGND VPWR VPWR sky130_fd_sc_hd__fill_1
XFILLER_42_474 VGND VGND VPWR VPWR sky130_fd_sc_hd__fill_2
Xinput37 load_base_addr[21] VGND VGND VPWR VPWR net37 sky130_fd_sc_hd__clkbuf_1
Xinput26 load_base_addr[11] VGND VGND VPWR VPWR net26 sky130_fd_sc_hd__clkbuf_1
Xinput15 count[21] VGND VGND VPWR VPWR net15 sky130_fd_sc_hd__buf_1
XTAP_TAPCELL_ROW_12_366 VGND VPWR sky130_fd_sc_hd__tapvpwrvgnd_1
XTAP_TAPCELL_ROW_40_675 VGND VPWR sky130_fd_sc_hd__tapvpwrvgnd_1
Xinput48 load_data[10] VGND VGND VPWR VPWR net48 sky130_fd_sc_hd__clkbuf_1
Xinput59 load_data[20] VGND VGND VPWR VPWR net59 sky130_fd_sc_hd__clkbuf_1
XTAP_TAPCELL_ROW_75_1051 VGND VPWR sky130_fd_sc_hd__tapvpwrvgnd_1
XFILLER_97_625 VGND VGND VPWR VPWR sky130_fd_sc_hd__fill_1
X_2340_ lsu.store_counter\[20\] _1568_ _1572_ lsu.store_counter\[21\] VGND VGND VPWR
+ VPWR _1779_ sky130_fd_sc_hd__o22ai_1
X_2271_ lsu.store_counter\[21\] _1735_ net266 VGND VGND VPWR VPWR _1736_ sky130_fd_sc_hd__a21o_1
XFILLER_69_349 VGND VGND VPWR VPWR sky130_fd_sc_hd__fill_1
XFILLER_2_581 VGND VGND VPWR VPWR sky130_fd_sc_hd__decap_6
X_4010_ lsu.store_fifo.queue\[8\]\[9\] lsu.store_fifo.queue\[9\]\[9\] lsu.store_fifo.queue\[10\]\[9\]
+ lsu.store_fifo.queue\[11\]\[9\] net412 net407 VGND VGND VPWR VPWR _1450_ sky130_fd_sc_hd__mux4_1
XFILLER_77_393 VPWR VGND VPWR VGND sky130_ef_sc_hd__decap_12
XTAP_TAPCELL_ROW_48_753 VGND VPWR sky130_fd_sc_hd__tapvpwrvgnd_1
XTAP_TAPCELL_ROW_86_1180 VGND VPWR sky130_fd_sc_hd__tapvpwrvgnd_1
X_4912_ clknet_leaf_31_clk _0967_ VGND VGND VPWR VPWR lsu.load_fifo.queue\[13\]\[7\]
+ sky130_fd_sc_hd__dfxtp_1
X_4843_ clknet_leaf_45_clk _0900_ _0093_ VGND VGND VPWR VPWR lsu.store_counter\[20\]
+ sky130_fd_sc_hd__dfrtp_1
XFILLER_20_102 VGND VGND VPWR VPWR sky130_fd_sc_hd__decap_6
XFILLER_21_625 VGND VGND VPWR VPWR sky130_fd_sc_hd__fill_2
XFILLER_60_282 VGND VGND VPWR VPWR sky130_fd_sc_hd__fill_1
X_4774_ clknet_leaf_44_clk net925 VGND VGND VPWR VPWR net139 sky130_fd_sc_hd__dfxtp_1
X_3725_ acc.byte3\[1\] acc.byte2\[1\] VGND VGND VPWR VPWR _1207_ sky130_fd_sc_hd__nand2_1
Xclkbuf_leaf_9_clk clknet_3_1__leaf_clk VGND VGND VPWR VPWR clknet_leaf_9_clk sky130_fd_sc_hd__clkbuf_8
X_3656_ acc.byte1\[3\] acc.byte0\[3\] VGND VGND VPWR VPWR _1138_ sky130_fd_sc_hd__or2_1
X_2607_ lsu.current_load_addr\[0\] _1991_ net161 VGND VGND VPWR VPWR _0727_ sky130_fd_sc_hd__mux2_4
X_3587_ net422 VGND VGND VPWR VPWR _0151_ sky130_fd_sc_hd__inv_2
X_2538_ lsu.current_load_addr\[18\] _1930_ VGND VGND VPWR VPWR _1941_ sky130_fd_sc_hd__or2_1
XFILLER_0_529 VGND VGND VPWR VPWR sky130_fd_sc_hd__decap_3
XFILLER_87_113 VGND VGND VPWR VPWR sky130_fd_sc_hd__decap_4
XTAP_TAPCELL_ROW_89_1209 VGND VPWR sky130_fd_sc_hd__tapvpwrvgnd_1
X_2469_ net252 _1891_ VGND VGND VPWR VPWR _1892_ sky130_fd_sc_hd__nor2_1
X_4208_ clknet_leaf_54_clk _0265_ VGND VGND VPWR VPWR lsu.store_fifo.queue\[6\]\[6\]
+ sky130_fd_sc_hd__dfxtp_1
XFILLER_83_341 VGND VGND VPWR VPWR sky130_fd_sc_hd__decap_4
X_4139_ clknet_leaf_65_clk _0196_ VGND VGND VPWR VPWR lsu.store_fifo.queue\[10\]\[9\]
+ sky130_fd_sc_hd__dfxtp_1
XFILLER_28_257 VGND VGND VPWR VPWR sky130_fd_sc_hd__fill_1
XFILLER_56_533 VGND VGND VPWR VPWR sky130_fd_sc_hd__decap_8
XFILLER_83_385 VGND VGND VPWR VPWR sky130_fd_sc_hd__decap_6
XFILLER_71_503 VGND VGND VPWR VPWR sky130_fd_sc_hd__fill_1
XFILLER_16_419 VGND VGND VPWR VPWR sky130_fd_sc_hd__fill_1
XFILLER_56_577 VGND VGND VPWR VPWR sky130_fd_sc_hd__fill_1
XFILLER_56_599 VGND VGND VPWR VPWR sky130_fd_sc_hd__fill_1
XFILLER_12_625 VGND VGND VPWR VPWR sky130_fd_sc_hd__decap_4
XFILLER_24_485 VGND VGND VPWR VPWR sky130_fd_sc_hd__fill_1
XFILLER_8_629 VGND VGND VPWR VPWR sky130_fd_sc_hd__fill_1
XFILLER_22_53 VGND VGND VPWR VPWR sky130_fd_sc_hd__decap_4
XFILLER_3_389 VGND VGND VPWR VPWR sky130_fd_sc_hd__decap_3
XFILLER_93_105 VGND VGND VPWR VPWR sky130_fd_sc_hd__decap_6
Xfanout192 _2040_ VGND VGND VPWR VPWR net192 sky130_fd_sc_hd__buf_2
Xfanout181 _2045_ VGND VGND VPWR VPWR net181 sky130_fd_sc_hd__buf_4
Xfanout170 _2056_ VGND VGND VPWR VPWR net170 sky130_fd_sc_hd__clkbuf_4
XFILLER_93_149 VPWR VGND VPWR VGND sky130_ef_sc_hd__decap_12
XFILLER_74_341 VGND VGND VPWR VPWR sky130_fd_sc_hd__fill_2
XFILLER_47_61 VGND VGND VPWR VPWR sky130_fd_sc_hd__fill_1
XFILLER_59_393 VGND VGND VPWR VPWR sky130_fd_sc_hd__fill_2
XFILLER_19_279 VGND VGND VPWR VPWR sky130_fd_sc_hd__fill_1
XFILLER_47_577 VGND VGND VPWR VPWR sky130_fd_sc_hd__decap_6
XFILLER_62_503 VGND VGND VPWR VPWR sky130_fd_sc_hd__decap_6
XFILLER_62_525 VGND VGND VPWR VPWR sky130_fd_sc_hd__decap_6
XTAP_TAPCELL_ROW_17_414 VGND VPWR sky130_fd_sc_hd__tapvpwrvgnd_1
XTAP_TAPCELL_ROW_45_723 VGND VPWR sky130_fd_sc_hd__tapvpwrvgnd_1
XFILLER_15_485 VPWR VGND VPWR VGND sky130_ef_sc_hd__decap_12
Xclkbuf_3_4__f_clk clknet_0_clk VGND VGND VPWR VPWR clknet_3_4__leaf_clk sky130_fd_sc_hd__clkbuf_16
XFILLER_42_282 VGND VGND VPWR VPWR sky130_fd_sc_hd__decap_8
XFILLER_8_33 VGND VGND VPWR VPWR sky130_fd_sc_hd__fill_1
XFILLER_8_55 VGND VGND VPWR VPWR sky130_fd_sc_hd__decap_4
X_3510_ net435 VGND VGND VPWR VPWR _0074_ sky130_fd_sc_hd__inv_2
X_4490_ clknet_leaf_21_clk _0547_ VGND VGND VPWR VPWR lsu.load_fifo.queue\[2\]\[2\]
+ sky130_fd_sc_hd__dfxtp_1
Xhold618 lsu.load_fifo.queue\[14\]\[3\] VGND VGND VPWR VPWR net1086 sky130_fd_sc_hd__dlygate4sd3_1
Xhold607 lsu.load_fifo.queue\[15\]\[26\] VGND VGND VPWR VPWR net1075 sky130_fd_sc_hd__dlygate4sd3_1
X_3441_ net436 VGND VGND VPWR VPWR _0005_ sky130_fd_sc_hd__inv_2
XFILLER_6_194 VGND VGND VPWR VPWR sky130_fd_sc_hd__fill_2
Xhold629 lsu.store_fifo.queue\[8\]\[7\] VGND VGND VPWR VPWR net1097 sky130_fd_sc_hd__dlygate4sd3_1
X_3372_ net312 net1000 net171 VGND VGND VPWR VPWR _0981_ sky130_fd_sc_hd__mux2_1
X_2323_ _1720_ _1725_ VGND VGND VPWR VPWR _1768_ sky130_fd_sc_hd__and2_1
XFILLER_69_113 VGND VGND VPWR VPWR sky130_fd_sc_hd__decap_3
X_2254_ lsu.storer_state\[2\] _1713_ VGND VGND VPWR VPWR _1719_ sky130_fd_sc_hd__nand2_2
X_5042_ clknet_leaf_54_clk net499 _0176_ VGND VGND VPWR VPWR acc.state sky130_fd_sc_hd__dfrtp_1
X_2185_ lsu.load_counter\[17\] lsu.load_counter\[16\] _1674_ VGND VGND VPWR VPWR _1675_
+ sky130_fd_sc_hd__and3_1
XFILLER_38_544 VGND VGND VPWR VPWR sky130_fd_sc_hd__decap_4
XFILLER_53_558 VGND VGND VPWR VPWR sky130_fd_sc_hd__fill_2
X_4826_ clknet_leaf_36_clk _0883_ _0076_ VGND VGND VPWR VPWR lsu.store_counter\[3\]
+ sky130_fd_sc_hd__dfrtp_1
X_4757_ clknet_leaf_48_clk net749 VGND VGND VPWR VPWR net142 sky130_fd_sc_hd__dfxtp_1
X_4688_ clknet_leaf_38_clk _0745_ _0034_ VGND VGND VPWR VPWR lsu.current_load_addr\[18\]
+ sky130_fd_sc_hd__dfrtp_1
X_3708_ _1184_ _1185_ VGND VGND VPWR VPWR _1190_ sky130_fd_sc_hd__xor2_1
X_3639_ net4 VGND VGND VPWR VPWR _1121_ sky130_fd_sc_hd__inv_2
XTAP_TAPCELL_ROW_95_1279 VGND VPWR sky130_fd_sc_hd__tapvpwrvgnd_1
XFILLER_0_337 VGND VGND VPWR VPWR sky130_fd_sc_hd__decap_8
XFILLER_88_477 VPWR VGND VPWR VGND sky130_ef_sc_hd__decap_12
XFILLER_84_26 VGND VGND VPWR VPWR sky130_fd_sc_hd__fill_2
XFILLER_56_363 VGND VGND VPWR VPWR sky130_fd_sc_hd__fill_1
XFILLER_71_333 VGND VGND VPWR VPWR sky130_fd_sc_hd__decap_3
XFILLER_16_249 VGND VGND VPWR VPWR sky130_fd_sc_hd__decap_3
XTAP_TAPCELL_ROW_104_1375 VGND VPWR sky130_fd_sc_hd__tapvpwrvgnd_1
XFILLER_12_433 VPWR VGND VPWR VGND sky130_ef_sc_hd__decap_12
XFILLER_12_477 VPWR VGND VPWR VGND sky130_ef_sc_hd__decap_12
XFILLER_8_415 VGND VGND VPWR VPWR sky130_fd_sc_hd__decap_4
XTAP_TAPCELL_ROW_22_472 VGND VPWR sky130_fd_sc_hd__tapvpwrvgnd_1
XTAP_TAPCELL_ROW_50_781 VGND VPWR sky130_fd_sc_hd__tapvpwrvgnd_1
XFILLER_3_142 VGND VGND VPWR VPWR sky130_fd_sc_hd__fill_1
XTAP_TAPCELL_ROW_72_1021 VGND VPWR sky130_fd_sc_hd__tapvpwrvgnd_1
XTAP_TAPCELL_ROW_58_870 VGND VPWR sky130_fd_sc_hd__tapvpwrvgnd_1
XFILLER_74_81 VGND VGND VPWR VPWR sky130_fd_sc_hd__decap_3
X_3990_ lsu.load_fifo.queue\[12\]\[1\] lsu.load_fifo.queue\[13\]\[1\] lsu.load_fifo.queue\[14\]\[1\]
+ lsu.load_fifo.queue\[15\]\[1\] net389 net372 VGND VGND VPWR VPWR _1432_ sky130_fd_sc_hd__mux4_1
X_2941_ net348 net1204 net214 VGND VGND VPWR VPWR _0452_ sky130_fd_sc_hd__mux2_1
XFILLER_88_3 VPWR VGND VPWR VGND sky130_ef_sc_hd__decap_12
X_4611_ clknet_leaf_80_clk _0668_ VGND VGND VPWR VPWR lsu.load_fifo.queue\[8\]\[27\]
+ sky130_fd_sc_hd__dfxtp_1
X_2872_ net813 net354 net196 VGND VGND VPWR VPWR _0383_ sky130_fd_sc_hd__mux2_1
X_4542_ clknet_leaf_71_clk _0599_ VGND VGND VPWR VPWR lsu.load_fifo.queue\[1\]\[22\]
+ sky130_fd_sc_hd__dfxtp_1
Xhold426 lsu.load_fifo.queue\[14\]\[24\] VGND VGND VPWR VPWR net894 sky130_fd_sc_hd__dlygate4sd3_1
Xhold415 lsu.load_fifo.queue\[11\]\[11\] VGND VGND VPWR VPWR net883 sky130_fd_sc_hd__dlygate4sd3_1
X_4473_ clknet_leaf_69_clk _0530_ VGND VGND VPWR VPWR lsu.load_fifo.queue\[3\]\[17\]
+ sky130_fd_sc_hd__dfxtp_1
Xhold404 lsu.load_fifo.queue\[12\]\[26\] VGND VGND VPWR VPWR net872 sky130_fd_sc_hd__dlygate4sd3_1
XFILLER_89_219 VGND VGND VPWR VPWR sky130_fd_sc_hd__decap_4
Xhold459 _0832_ VGND VGND VPWR VPWR net927 sky130_fd_sc_hd__dlygate4sd3_1
Xhold437 lsu.load_fifo.queue\[14\]\[2\] VGND VGND VPWR VPWR net905 sky130_fd_sc_hd__dlygate4sd3_1
Xhold448 lsu.load_fifo.queue\[9\]\[18\] VGND VGND VPWR VPWR net916 sky130_fd_sc_hd__dlygate4sd3_1
X_3424_ net277 net652 _2058_ VGND VGND VPWR VPWR _1073_ sky130_fd_sc_hd__mux2_1
X_3355_ net346 net1001 net171 VGND VGND VPWR VPWR _0964_ sky130_fd_sc_hd__mux2_1
X_2306_ _1755_ _1757_ VGND VGND VPWR VPWR _0889_ sky130_fd_sc_hd__and2_1
X_3286_ net1252 net58 net248 VGND VGND VPWR VPWR _0848_ sky130_fd_sc_hd__mux2_1
X_2237_ net1306 _1707_ _1705_ VGND VGND VPWR VPWR _0908_ sky130_fd_sc_hd__o21ba_1
XFILLER_85_469 VGND VGND VPWR VPWR sky130_fd_sc_hd__fill_2
X_5025_ clknet_leaf_55_clk _1080_ _0169_ VGND VGND VPWR VPWR acc.data_out\[4\] sky130_fd_sc_hd__dfrtp_1
X_2168_ _1631_ _1636_ _1642_ _1657_ VGND VGND VPWR VPWR _1658_ sky130_fd_sc_hd__and4b_1
X_2099_ lsu.load_counter\[14\] _1563_ _1587_ VGND VGND VPWR VPWR _1589_ sky130_fd_sc_hd__and3_1
XPHY_EDGE_ROW_17_Right_17 VGND VGND VPWR VPWR sky130_fd_sc_hd__decap_3
X_4809_ clknet_leaf_3_clk _0866_ VGND VGND VPWR VPWR lsu.load_fifo.data_in\[19\] sky130_fd_sc_hd__dfxtp_1
XFILLER_5_429 VPWR VGND VPWR VGND sky130_ef_sc_hd__decap_12
XPHY_EDGE_ROW_26_Right_26 VGND VGND VPWR VPWR sky130_fd_sc_hd__decap_3
XFILLER_95_69 VPWR VGND VPWR VGND sky130_ef_sc_hd__decap_12
XFILLER_0_189 VGND VGND VPWR VPWR sky130_fd_sc_hd__decap_3
XFILLER_17_503 VGND VGND VPWR VPWR sky130_fd_sc_hd__fill_1
XTAP_TAPCELL_ROW_106_1404 VGND VPWR sky130_fd_sc_hd__tapvpwrvgnd_1
XFILLER_84_480 VPWR VGND VPWR VGND sky130_ef_sc_hd__decap_12
XTAP_TAPCELL_ROW_27_531 VGND VPWR sky130_fd_sc_hd__tapvpwrvgnd_1
XFILLER_44_333 VPWR VGND VPWR VGND sky130_ef_sc_hd__decap_12
XTAP_TAPCELL_ROW_55_840 VGND VPWR sky130_fd_sc_hd__tapvpwrvgnd_1
XFILLER_32_517 VPWR VGND VPWR VGND sky130_ef_sc_hd__decap_12
XFILLER_25_591 VPWR VGND VPWR VGND sky130_ef_sc_hd__decap_12
XPHY_EDGE_ROW_35_Right_35 VGND VGND VPWR VPWR sky130_fd_sc_hd__decap_3
XFILLER_12_296 VGND VGND VPWR VPWR sky130_fd_sc_hd__fill_1
XPHY_EDGE_ROW_44_Right_44 VGND VGND VPWR VPWR sky130_fd_sc_hd__decap_3
X_3140_ net682 net353 net178 VGND VGND VPWR VPWR _0642_ sky130_fd_sc_hd__mux2_1
XFILLER_39_105 VGND VGND VPWR VPWR sky130_fd_sc_hd__decap_6
XFILLER_94_233 VPWR VGND VPWR VGND sky130_ef_sc_hd__decap_12
XFILLER_67_447 VGND VGND VPWR VPWR sky130_fd_sc_hd__fill_1
XFILLER_94_277 VPWR VGND VPWR VGND sky130_ef_sc_hd__decap_12
X_3071_ net930 net292 net207 VGND VGND VPWR VPWR _0576_ sky130_fd_sc_hd__mux2_1
XFILLER_47_193 VPWR VGND VPWR VGND sky130_ef_sc_hd__decap_12
XFILLER_50_358 VGND VGND VPWR VPWR sky130_fd_sc_hd__decap_6
XPHY_EDGE_ROW_53_Right_53 VGND VGND VPWR VPWR sky130_fd_sc_hd__decap_3
X_3973_ _1417_ _1416_ net364 VGND VGND VPWR VPWR _1418_ sky130_fd_sc_hd__mux2_1
XFILLER_31_572 VGND VGND VPWR VPWR sky130_fd_sc_hd__fill_2
X_2924_ net1062 net316 net218 VGND VGND VPWR VPWR _0436_ sky130_fd_sc_hd__mux2_1
XTAP_TAPCELL_ROW_33_589 VGND VPWR sky130_fd_sc_hd__tapvpwrvgnd_1
X_2855_ net1066 net324 net224 VGND VGND VPWR VPWR _0366_ sky130_fd_sc_hd__mux2_1
XTAP_TAPCELL_ROW_61_898 VGND VPWR sky130_fd_sc_hd__tapvpwrvgnd_1
X_2786_ net655 net286 _2031_ VGND VGND VPWR VPWR _0301_ sky130_fd_sc_hd__mux2_1
X_4525_ clknet_leaf_6_clk _0582_ VGND VGND VPWR VPWR lsu.load_fifo.queue\[1\]\[5\]
+ sky130_fd_sc_hd__dfxtp_1
Xhold201 lsu.load_fifo.queue\[12\]\[28\] VGND VGND VPWR VPWR net669 sky130_fd_sc_hd__dlygate4sd3_1
Xhold234 lsu.load_fifo.queue\[12\]\[19\] VGND VGND VPWR VPWR net702 sky130_fd_sc_hd__dlygate4sd3_1
Xhold223 net141 VGND VGND VPWR VPWR net691 sky130_fd_sc_hd__dlygate4sd3_1
Xhold212 lsu.load_fifo.queue\[8\]\[8\] VGND VGND VPWR VPWR net680 sky130_fd_sc_hd__dlygate4sd3_1
XTAP_TAPCELL_ROW_92_1238 VGND VPWR sky130_fd_sc_hd__tapvpwrvgnd_1
X_4456_ clknet_leaf_35_clk _0513_ VGND VGND VPWR VPWR lsu.load_fifo.queue\[3\]\[0\]
+ sky130_fd_sc_hd__dfxtp_1
Xhold267 lsu.load_fifo.queue\[2\]\[1\] VGND VGND VPWR VPWR net735 sky130_fd_sc_hd__dlygate4sd3_1
Xhold278 lsu.store_fifo.queue\[6\]\[9\] VGND VGND VPWR VPWR net746 sky130_fd_sc_hd__dlygate4sd3_1
Xhold256 lsu.store_fifo.queue\[13\]\[5\] VGND VGND VPWR VPWR net724 sky130_fd_sc_hd__dlygate4sd3_1
Xhold245 lsu.load_fifo.queue\[13\]\[12\] VGND VGND VPWR VPWR net713 sky130_fd_sc_hd__dlygate4sd3_1
XPHY_EDGE_ROW_62_Right_62 VGND VGND VPWR VPWR sky130_fd_sc_hd__decap_3
X_3407_ net827 net308 net199 VGND VGND VPWR VPWR _1057_ sky130_fd_sc_hd__mux2_1
X_4387_ clknet_leaf_82_clk _0444_ VGND VGND VPWR VPWR lsu.load_fifo.queue\[6\]\[27\]
+ sky130_fd_sc_hd__dfxtp_1
Xhold289 lsu.store_fifo.queue\[2\]\[4\] VGND VGND VPWR VPWR net757 sky130_fd_sc_hd__dlygate4sd3_1
X_3338_ net788 net315 net173 VGND VGND VPWR VPWR _0948_ sky130_fd_sc_hd__mux2_1
XFILLER_105_57 VGND VGND VPWR VPWR sky130_fd_sc_hd__fill_2
XFILLER_100_533 VGND VGND VPWR VPWR sky130_fd_sc_hd__decap_8
X_3269_ lsu.current_store_addr\[18\] net922 net258 VGND VGND VPWR VPWR _0829_ sky130_fd_sc_hd__mux2_1
XTAP_TAPCELL_ROW_69_987 VGND VPWR sky130_fd_sc_hd__tapvpwrvgnd_1
X_5008_ clknet_leaf_23_clk _1063_ VGND VGND VPWR VPWR lsu.load_fifo.queue\[14\]\[29\]
+ sky130_fd_sc_hd__dfxtp_1
XPHY_EDGE_ROW_71_Right_71 VGND VGND VPWR VPWR sky130_fd_sc_hd__decap_3
XTAP_TAPCELL_ROW_101_1345 VGND VPWR sky130_fd_sc_hd__tapvpwrvgnd_1
XFILLER_14_54 VGND VGND VPWR VPWR sky130_fd_sc_hd__decap_6
XPHY_EDGE_ROW_80_Right_80 VGND VGND VPWR VPWR sky130_fd_sc_hd__decap_3
Xhold790 acc.byte3\[2\] VGND VGND VPWR VPWR net1258 sky130_fd_sc_hd__dlygate4sd3_1
XFILLER_91_225 VPWR VGND VPWR VGND sky130_ef_sc_hd__decap_12
XTAP_TAPCELL_ROW_4_270 VGND VPWR sky130_fd_sc_hd__tapvpwrvgnd_1
XFILLER_17_333 VGND VGND VPWR VPWR sky130_fd_sc_hd__decap_3
XFILLER_13_561 VPWR VGND VPWR VGND sky130_ef_sc_hd__decap_12
XFILLER_20_509 VPWR VGND VPWR VGND sky130_ef_sc_hd__decap_12
XTAP_TAPCELL_ROW_30_559 VGND VPWR sky130_fd_sc_hd__tapvpwrvgnd_1
X_2640_ lsu.store_fifo.w_ptr\[3\] _1115_ VGND VGND VPWR VPWR _2016_ sky130_fd_sc_hd__nand2_2
X_2571_ net25 net260 _1964_ _1965_ VGND VGND VPWR VPWR _1966_ sky130_fd_sc_hd__a22o_1
X_4310_ clknet_leaf_31_clk _0367_ VGND VGND VPWR VPWR lsu.load_fifo.queue\[10\]\[16\]
+ sky130_fd_sc_hd__dfxtp_1
XTAP_TAPCELL_ROW_78_1093 VGND VPWR sky130_fd_sc_hd__tapvpwrvgnd_1
XFILLER_99_369 VGND VGND VPWR VPWR sky130_fd_sc_hd__decap_4
X_4241_ clknet_leaf_70_clk _0298_ VGND VGND VPWR VPWR lsu.store_fifo.queue\[3\]\[9\]
+ sky130_fd_sc_hd__dfxtp_1
X_4172_ clknet_leaf_46_clk _0229_ VGND VGND VPWR VPWR lsu.store_fifo.queue\[9\]\[0\]
+ sky130_fd_sc_hd__dfxtp_1
X_3123_ net1237 net321 net182 VGND VGND VPWR VPWR _0626_ sky130_fd_sc_hd__mux2_1
X_3054_ net864 net327 net206 VGND VGND VPWR VPWR _0559_ sky130_fd_sc_hd__mux2_1
XTAP_TAPCELL_ROW_66_957 VGND VPWR sky130_fd_sc_hd__tapvpwrvgnd_1
XTAP_TAPCELL_ROW_38_648 VGND VPWR sky130_fd_sc_hd__tapvpwrvgnd_1
X_3956_ _1401_ _1402_ net360 VGND VGND VPWR VPWR _1403_ sky130_fd_sc_hd__mux2_1
X_2907_ net798 net350 net220 VGND VGND VPWR VPWR _0419_ sky130_fd_sc_hd__mux2_1
X_3887_ lsu.load_fifo.queue\[8\]\[16\] lsu.load_fifo.queue\[9\]\[16\] lsu.load_fifo.queue\[10\]\[16\]
+ lsu.load_fifo.queue\[11\]\[16\] net396 net379 VGND VGND VPWR VPWR _1344_ sky130_fd_sc_hd__mux4_1
X_2838_ lsu.load_fifo.w_ptr\[0\] _1996_ lsu.load_fifo.w_ptr\[1\] VGND VGND VPWR VPWR
+ _2034_ sky130_fd_sc_hd__and3b_1
X_2769_ net1027 net274 _2028_ VGND VGND VPWR VPWR _0287_ sky130_fd_sc_hd__mux2_1
XFILLER_105_625 VGND VGND VPWR VPWR sky130_fd_sc_hd__fill_2
X_4508_ clknet_leaf_85_clk _0565_ VGND VGND VPWR VPWR lsu.load_fifo.queue\[2\]\[20\]
+ sky130_fd_sc_hd__dfxtp_1
XFILLER_2_218 VPWR VGND VPWR VGND sky130_ef_sc_hd__decap_12
X_4439_ clknet_leaf_11_clk _0496_ VGND VGND VPWR VPWR lsu.load_fifo.queue\[4\]\[15\]
+ sky130_fd_sc_hd__dfxtp_1
XFILLER_104_179 VGND VGND VPWR VPWR sky130_fd_sc_hd__fill_1
XFILLER_104_157 VGND VGND VPWR VPWR sky130_fd_sc_hd__fill_2
XFILLER_100_330 VGND VGND VPWR VPWR sky130_fd_sc_hd__fill_1
XFILLER_100_363 VGND VGND VPWR VPWR sky130_fd_sc_hd__fill_1
XFILLER_86_586 VGND VGND VPWR VPWR sky130_fd_sc_hd__fill_2
XFILLER_92_15 VPWR VGND VPWR VGND sky130_ef_sc_hd__decap_12
XTAP_TAPCELL_ROW_1_240 VGND VPWR sky130_fd_sc_hd__tapvpwrvgnd_1
XFILLER_26_141 VGND VGND VPWR VPWR sky130_fd_sc_hd__decap_6
XFILLER_54_472 VGND VGND VPWR VPWR sky130_fd_sc_hd__decap_4
XFILLER_14_347 VGND VGND VPWR VPWR sky130_fd_sc_hd__fill_1
XFILLER_14_325 VGND VGND VPWR VPWR sky130_fd_sc_hd__decap_8
XFILLER_41_111 VGND VGND VPWR VPWR sky130_fd_sc_hd__fill_1
XFILLER_10_531 VGND VGND VPWR VPWR sky130_fd_sc_hd__fill_1
XFILLER_6_513 VPWR VGND VPWR VGND sky130_ef_sc_hd__decap_12
XFILLER_6_557 VPWR VGND VPWR VGND sky130_ef_sc_hd__decap_12
XPHY_EDGE_ROW_102_Left_209 VGND VGND VPWR VPWR sky130_fd_sc_hd__decap_3
XFILLER_89_391 VGND VGND VPWR VPWR sky130_fd_sc_hd__fill_1
XFILLER_77_597 VGND VGND VPWR VPWR sky130_fd_sc_hd__decap_4
XTAP_TAPCELL_ROW_35_618 VGND VPWR sky130_fd_sc_hd__tapvpwrvgnd_1
XTAP_TAPCELL_ROW_63_927 VGND VPWR sky130_fd_sc_hd__tapvpwrvgnd_1
XFILLER_64_269 VGND VGND VPWR VPWR sky130_fd_sc_hd__fill_2
XFILLER_17_196 VGND VGND VPWR VPWR sky130_fd_sc_hd__fill_2
X_4790_ clknet_leaf_30_clk _0847_ VGND VGND VPWR VPWR lsu.load_fifo.data_in\[0\] sky130_fd_sc_hd__dfxtp_1
XFILLER_82_70 VGND VGND VPWR VPWR sky130_fd_sc_hd__decap_4
X_3810_ _1276_ _1277_ net361 VGND VGND VPWR VPWR _1278_ sky130_fd_sc_hd__mux2_1
X_3741_ _1204_ _1222_ _1203_ VGND VGND VPWR VPWR _1223_ sky130_fd_sc_hd__a21o_1
XTAP_TAPCELL_ROW_15_397 VGND VPWR sky130_fd_sc_hd__tapvpwrvgnd_1
XFILLER_70_3 VGND VGND VPWR VPWR sky130_fd_sc_hd__decap_6
X_3672_ _1132_ _1153_ _1130_ VGND VGND VPWR VPWR _1154_ sky130_fd_sc_hd__o21ai_2
X_2623_ net418 _1998_ VGND VGND VPWR VPWR _2002_ sky130_fd_sc_hd__or2_1
Xoutput114 net114 VGND VGND VPWR VPWR load_addr[19] sky130_fd_sc_hd__buf_2
Xoutput125 net125 VGND VGND VPWR VPWR load_addr[9] sky130_fd_sc_hd__buf_2
X_2554_ net259 _1928_ VGND VGND VPWR VPWR _1953_ sky130_fd_sc_hd__nor2_1
XFILLER_99_111 VGND VGND VPWR VPWR sky130_fd_sc_hd__fill_1
Xoutput103 net103 VGND VGND VPWR VPWR done sky130_fd_sc_hd__buf_2
Xoutput136 net136 VGND VGND VPWR VPWR store_addr[18] sky130_fd_sc_hd__buf_2
Xoutput158 net158 VGND VGND VPWR VPWR store_data[9] sky130_fd_sc_hd__buf_2
Xoutput147 net147 VGND VGND VPWR VPWR store_addr[8] sky130_fd_sc_hd__buf_2
XFILLER_99_155 VGND VGND VPWR VPWR sky130_fd_sc_hd__decap_6
X_2485_ net267 _1841_ net238 VGND VGND VPWR VPWR _1903_ sky130_fd_sc_hd__o21a_1
X_4224_ clknet_leaf_57_clk _0281_ VGND VGND VPWR VPWR lsu.store_fifo.queue\[4\]\[2\]
+ sky130_fd_sc_hd__dfxtp_1
XFILLER_68_575 VPWR VGND VPWR VGND sky130_ef_sc_hd__decap_12
X_4155_ clknet_leaf_10_clk _0212_ VGND VGND VPWR VPWR lsu.load_fifo.queue\[11\]\[15\]
+ sky130_fd_sc_hd__dfxtp_1
XFILLER_95_383 VGND VGND VPWR VPWR sky130_fd_sc_hd__decap_8
X_3106_ net786 net355 net184 VGND VGND VPWR VPWR _0609_ sky130_fd_sc_hd__mux2_1
X_4086_ net402 _1518_ VGND VGND VPWR VPWR _1519_ sky130_fd_sc_hd__nor2_1
XFILLER_24_601 VPWR VGND VPWR VGND sky130_ef_sc_hd__decap_12
X_3037_ net636 net295 net212 VGND VGND VPWR VPWR _0543_ sky130_fd_sc_hd__mux2_1
XFILLER_62_29 VGND VGND VPWR VPWR sky130_fd_sc_hd__decap_6
X_4988_ clknet_leaf_83_clk _1043_ VGND VGND VPWR VPWR lsu.load_fifo.queue\[14\]\[9\]
+ sky130_fd_sc_hd__dfxtp_1
XFILLER_23_177 VGND VGND VPWR VPWR sky130_fd_sc_hd__decap_4
X_3939_ acc.byte1\[1\] _1388_ net254 VGND VGND VPWR VPWR _1011_ sky130_fd_sc_hd__mux2_1
XFILLER_3_505 VPWR VGND VPWR VGND sky130_ef_sc_hd__decap_12
XFILLER_87_15 VPWR VGND VPWR VGND sky130_ef_sc_hd__decap_12
XFILLER_78_306 VGND VGND VPWR VPWR sky130_fd_sc_hd__fill_2
XFILLER_78_328 VGND VGND VPWR VPWR sky130_fd_sc_hd__fill_1
Xfanout341 lsu.load_fifo.data_in\[7\] VGND VGND VPWR VPWR net341 sky130_fd_sc_hd__buf_1
Xfanout330 lsu.load_fifo.data_in\[12\] VGND VGND VPWR VPWR net330 sky130_fd_sc_hd__clkbuf_2
Xfanout352 net353 VGND VGND VPWR VPWR net352 sky130_fd_sc_hd__clkbuf_2
Xfanout374 net375 VGND VGND VPWR VPWR net374 sky130_fd_sc_hd__clkbuf_4
Xfanout363 net365 VGND VGND VPWR VPWR net363 sky130_fd_sc_hd__clkbuf_4
Xfanout396 net398 VGND VGND VPWR VPWR net396 sky130_fd_sc_hd__buf_4
XFILLER_74_501 VPWR VGND VPWR VGND sky130_ef_sc_hd__decap_12
Xfanout385 net386 VGND VGND VPWR VPWR net385 sky130_fd_sc_hd__buf_4
XFILLER_74_556 VGND VGND VPWR VPWR sky130_fd_sc_hd__decap_8
XFILLER_74_589 VGND VGND VPWR VPWR sky130_fd_sc_hd__decap_3
XFILLER_46_269 VGND VGND VPWR VPWR sky130_fd_sc_hd__fill_1
XFILLER_14_100 VGND VGND VPWR VPWR sky130_fd_sc_hd__fill_1
XFILLER_42_442 VGND VGND VPWR VPWR sky130_fd_sc_hd__fill_2
Xinput16 count[2] VGND VGND VPWR VPWR net16 sky130_fd_sc_hd__buf_8
Xinput27 load_base_addr[12] VGND VGND VPWR VPWR net27 sky130_fd_sc_hd__clkbuf_1
XTAP_TAPCELL_ROW_12_367 VGND VPWR sky130_fd_sc_hd__tapvpwrvgnd_1
XTAP_TAPCELL_ROW_40_665 VGND VPWR sky130_fd_sc_hd__tapvpwrvgnd_1
Xinput38 load_base_addr[2] VGND VGND VPWR VPWR net38 sky130_fd_sc_hd__buf_1
XFILLER_6_321 VGND VGND VPWR VPWR sky130_fd_sc_hd__decap_3
Xinput49 load_data[11] VGND VGND VPWR VPWR net49 sky130_fd_sc_hd__clkbuf_1
XTAP_TAPCELL_ROW_75_1052 VGND VPWR sky130_fd_sc_hd__tapvpwrvgnd_1
X_2270_ lsu.store_counter\[20\] lsu.store_counter\[19\] lsu.store_counter\[18\] _1733_
+ VGND VGND VPWR VPWR _1735_ sky130_fd_sc_hd__and4_1
XFILLER_84_309 VGND VGND VPWR VPWR sky130_fd_sc_hd__fill_1
XFILLER_77_81 VGND VGND VPWR VPWR sky130_fd_sc_hd__decap_6
XTAP_TAPCELL_ROW_48_754 VGND VPWR sky130_fd_sc_hd__tapvpwrvgnd_1
XFILLER_65_556 VGND VGND VPWR VPWR sky130_fd_sc_hd__decap_4
XFILLER_37_258 VGND VGND VPWR VPWR sky130_fd_sc_hd__decap_3
XTAP_TAPCELL_ROW_86_1181 VGND VPWR sky130_fd_sc_hd__tapvpwrvgnd_1
X_4911_ clknet_leaf_1_clk _0966_ VGND VGND VPWR VPWR lsu.load_fifo.queue\[13\]\[6\]
+ sky130_fd_sc_hd__dfxtp_1
XFILLER_33_442 VGND VGND VPWR VPWR sky130_fd_sc_hd__decap_6
X_4842_ clknet_leaf_45_clk _0899_ _0092_ VGND VGND VPWR VPWR lsu.store_counter\[19\]
+ sky130_fd_sc_hd__dfrtp_1
XFILLER_21_615 VGND VGND VPWR VPWR sky130_fd_sc_hd__fill_1
X_4773_ clknet_leaf_43_clk _0830_ VGND VGND VPWR VPWR net137 sky130_fd_sc_hd__dfxtp_1
X_3724_ _1200_ _1201_ VGND VGND VPWR VPWR _1206_ sky130_fd_sc_hd__xor2_1
X_3655_ acc.byte1\[3\] acc.byte0\[3\] VGND VGND VPWR VPWR _1137_ sky130_fd_sc_hd__nand2_1
X_2606_ _1113_ net24 net259 VGND VGND VPWR VPWR _1991_ sky130_fd_sc_hd__mux2_1
X_3586_ net424 VGND VGND VPWR VPWR _0150_ sky130_fd_sc_hd__inv_2
X_2537_ _1112_ _1938_ _1940_ net477 VGND VGND VPWR VPWR _0746_ sky130_fd_sc_hd__a2bb2o_1
X_2468_ lsu.current_store_addr\[7\] _1846_ net265 VGND VGND VPWR VPWR _1891_ sky130_fd_sc_hd__a21oi_1
XFILLER_87_169 VGND VGND VPWR VPWR sky130_fd_sc_hd__fill_1
X_4207_ clknet_leaf_71_clk _0264_ VGND VGND VPWR VPWR lsu.store_fifo.queue\[6\]\[5\]
+ sky130_fd_sc_hd__dfxtp_1
X_2399_ lsu.load_fifo.w_en lsu.loader_state\[1\] lsu.loader_state\[0\] _1550_ VGND
+ VGND VPWR VPWR _0834_ sky130_fd_sc_hd__a31o_1
XFILLER_68_350 VGND VGND VPWR VPWR sky130_fd_sc_hd__decap_4
X_4138_ clknet_leaf_60_clk _0195_ VGND VGND VPWR VPWR lsu.store_fifo.queue\[10\]\[8\]
+ sky130_fd_sc_hd__dfxtp_1
XFILLER_83_353 VPWR VGND VPWR VGND sky130_ef_sc_hd__decap_12
XFILLER_43_206 VGND VGND VPWR VPWR sky130_fd_sc_hd__decap_8
X_4069_ net271 _1503_ VGND VGND VPWR VPWR _1504_ sky130_fd_sc_hd__nor2_1
XFILLER_71_559 VGND VGND VPWR VPWR sky130_fd_sc_hd__fill_1
XFILLER_43_228 VGND VGND VPWR VPWR sky130_fd_sc_hd__fill_2
XFILLER_24_475 VGND VGND VPWR VPWR sky130_fd_sc_hd__fill_1
XFILLER_3_335 VGND VGND VPWR VPWR sky130_fd_sc_hd__fill_1
XFILLER_0_3 VPWR VGND VPWR VGND sky130_ef_sc_hd__decap_12
XFILLER_3_346 VGND VGND VPWR VPWR sky130_fd_sc_hd__fill_1
Xfanout160 _1679_ VGND VGND VPWR VPWR net160 sky130_fd_sc_hd__buf_8
Xfanout171 _2056_ VGND VGND VPWR VPWR net171 sky130_fd_sc_hd__buf_4
Xfanout182 _2045_ VGND VGND VPWR VPWR net182 sky130_fd_sc_hd__buf_2
XFILLER_19_225 VGND VGND VPWR VPWR sky130_fd_sc_hd__fill_2
Xfanout193 _2000_ VGND VGND VPWR VPWR net193 sky130_fd_sc_hd__buf_4
XTAP_TAPCELL_ROW_17_415 VGND VPWR sky130_fd_sc_hd__tapvpwrvgnd_1
XTAP_TAPCELL_ROW_45_724 VGND VPWR sky130_fd_sc_hd__tapvpwrvgnd_1
XFILLER_15_497 VGND VGND VPWR VPWR sky130_fd_sc_hd__decap_6
Xhold608 lsu.load_fifo.queue\[14\]\[25\] VGND VGND VPWR VPWR net1076 sky130_fd_sc_hd__dlygate4sd3_1
X_3440_ net436 VGND VGND VPWR VPWR _0004_ sky130_fd_sc_hd__inv_2
Xhold619 lsu.store_fifo.queue\[1\]\[7\] VGND VGND VPWR VPWR net1087 sky130_fd_sc_hd__dlygate4sd3_1
X_3371_ net315 net1128 net169 VGND VGND VPWR VPWR _0980_ sky130_fd_sc_hd__mux2_1
XFILLER_88_80 VGND VGND VPWR VPWR sky130_fd_sc_hd__decap_4
X_2322_ net266 _1725_ net239 VGND VGND VPWR VPWR _1767_ sky130_fd_sc_hd__o21ai_1
XFILLER_33_3 VGND VGND VPWR VPWR sky130_fd_sc_hd__decap_8
X_5041_ clknet_leaf_54_clk net500 _0175_ VGND VGND VPWR VPWR acc.done sky130_fd_sc_hd__dfrtp_1
X_2253_ lsu.storer_state\[2\] _1713_ VGND VGND VPWR VPWR _1718_ sky130_fd_sc_hd__and2_1
X_2184_ lsu.load_counter\[15\] lsu.load_counter\[14\] _1673_ VGND VGND VPWR VPWR _1674_
+ sky130_fd_sc_hd__and3_1
XFILLER_65_353 VGND VGND VPWR VPWR sky130_fd_sc_hd__fill_1
X_4825_ clknet_leaf_36_clk _0882_ _0075_ VGND VGND VPWR VPWR lsu.store_counter\[2\]
+ sky130_fd_sc_hd__dfrtp_1
X_4756_ clknet_leaf_62_clk _0813_ VGND VGND VPWR VPWR net141 sky130_fd_sc_hd__dfxtp_1
X_4687_ clknet_leaf_28_clk _0744_ _0033_ VGND VGND VPWR VPWR lsu.current_load_addr\[17\]
+ sky130_fd_sc_hd__dfrtp_1
X_3707_ _1187_ _1188_ VGND VGND VPWR VPWR _1189_ sky130_fd_sc_hd__nand2b_1
X_3638_ net5 VGND VGND VPWR VPWR _1120_ sky130_fd_sc_hd__inv_2
XFILLER_88_401 VPWR VGND VPWR VGND sky130_ef_sc_hd__decap_12
X_3569_ net425 VGND VGND VPWR VPWR _0133_ sky130_fd_sc_hd__inv_2
XFILLER_0_349 VGND VGND VPWR VPWR sky130_fd_sc_hd__decap_4
XFILLER_88_489 VGND VGND VPWR VPWR sky130_fd_sc_hd__fill_1
XFILLER_90_109 VGND VGND VPWR VPWR sky130_fd_sc_hd__decap_8
XFILLER_29_556 VGND VGND VPWR VPWR sky130_fd_sc_hd__fill_1
XTAP_TAPCELL_ROW_104_1376 VGND VPWR sky130_fd_sc_hd__tapvpwrvgnd_1
XFILLER_12_445 VPWR VGND VPWR VGND sky130_ef_sc_hd__decap_12
XFILLER_24_294 VGND VGND VPWR VPWR sky130_fd_sc_hd__decap_3
XFILLER_33_42 VGND VGND VPWR VPWR sky130_fd_sc_hd__decap_6
XFILLER_12_489 VPWR VGND VPWR VGND sky130_ef_sc_hd__decap_12
XTAP_TAPCELL_ROW_22_473 VGND VPWR sky130_fd_sc_hd__tapvpwrvgnd_1
XTAP_TAPCELL_ROW_50_782 VGND VPWR sky130_fd_sc_hd__tapvpwrvgnd_1
XFILLER_106_561 VGND VGND VPWR VPWR sky130_fd_sc_hd__fill_2
XTAP_TAPCELL_ROW_72_1022 VGND VPWR sky130_fd_sc_hd__tapvpwrvgnd_1
XFILLER_94_404 VGND VGND VPWR VPWR sky130_fd_sc_hd__decap_6
XFILLER_67_629 VGND VGND VPWR VPWR sky130_fd_sc_hd__fill_1
XFILLER_94_437 VPWR VGND VPWR VGND sky130_ef_sc_hd__decap_12
XFILLER_66_139 VGND VGND VPWR VPWR sky130_fd_sc_hd__fill_1
XTAP_TAPCELL_ROW_58_871 VGND VPWR sky130_fd_sc_hd__tapvpwrvgnd_1
XFILLER_35_559 VGND VGND VPWR VPWR sky130_fd_sc_hd__fill_1
XTAP_TAPCELL_ROW_83_1140 VGND VPWR sky130_fd_sc_hd__tapvpwrvgnd_1
X_2940_ net350 net752 net216 VGND VGND VPWR VPWR _0451_ sky130_fd_sc_hd__mux2_1
XFILLER_15_261 VGND VGND VPWR VPWR sky130_fd_sc_hd__fill_1
XFILLER_50_529 VGND VGND VPWR VPWR sky130_fd_sc_hd__decap_3
X_2871_ net1033 net293 net223 VGND VGND VPWR VPWR _0382_ sky130_fd_sc_hd__mux2_1
X_4610_ clknet_leaf_13_clk _0667_ VGND VGND VPWR VPWR lsu.load_fifo.queue\[8\]\[26\]
+ sky130_fd_sc_hd__dfxtp_1
X_4541_ clknet_leaf_14_clk _0598_ VGND VGND VPWR VPWR lsu.load_fifo.queue\[1\]\[21\]
+ sky130_fd_sc_hd__dfxtp_1
X_4472_ clknet_leaf_31_clk _0529_ VGND VGND VPWR VPWR lsu.load_fifo.queue\[3\]\[16\]
+ sky130_fd_sc_hd__dfxtp_1
Xhold427 lsu.load_fifo.queue\[8\]\[18\] VGND VGND VPWR VPWR net895 sky130_fd_sc_hd__dlygate4sd3_1
Xhold405 lsu.store_fifo.queue\[0\]\[3\] VGND VGND VPWR VPWR net873 sky130_fd_sc_hd__dlygate4sd3_1
Xhold416 lsu.load_fifo.queue\[14\]\[12\] VGND VGND VPWR VPWR net884 sky130_fd_sc_hd__dlygate4sd3_1
Xhold449 lsu.load_fifo.queue\[1\]\[11\] VGND VGND VPWR VPWR net917 sky130_fd_sc_hd__dlygate4sd3_1
Xhold438 lsu.load_fifo.queue\[6\]\[26\] VGND VGND VPWR VPWR net906 sky130_fd_sc_hd__dlygate4sd3_1
X_3423_ net278 net1176 _2058_ VGND VGND VPWR VPWR _1072_ sky130_fd_sc_hd__mux2_1
X_3354_ net348 net1216 net169 VGND VGND VPWR VPWR _0963_ sky130_fd_sc_hd__mux2_1
X_3285_ net1249 net47 net251 VGND VGND VPWR VPWR _0847_ sky130_fd_sc_hd__mux2_1
X_2305_ lsu.store_counter\[8\] net239 _1728_ lsu.store_counter\[9\] VGND VGND VPWR
+ VPWR _1757_ sky130_fd_sc_hd__a31o_1
XFILLER_58_629 VGND VGND VPWR VPWR sky130_fd_sc_hd__fill_1
X_2236_ net478 net480 _1667_ net243 VGND VGND VPWR VPWR _1707_ sky130_fd_sc_hd__o211a_1
X_5024_ clknet_leaf_73_clk _1079_ _0168_ VGND VGND VPWR VPWR acc.data_out\[3\] sky130_fd_sc_hd__dfrtp_1
X_2167_ _1634_ _1637_ _1656_ VGND VGND VPWR VPWR _1657_ sky130_fd_sc_hd__and3b_1
XFILLER_65_161 VGND VGND VPWR VPWR sky130_fd_sc_hd__decap_6
X_2098_ net470 _1587_ lsu.load_counter\[14\] VGND VGND VPWR VPWR _1588_ sky130_fd_sc_hd__a21oi_1
XFILLER_80_120 VGND VGND VPWR VPWR sky130_fd_sc_hd__decap_3
XFILLER_21_264 VPWR VGND VPWR VGND sky130_ef_sc_hd__decap_12
X_4808_ clknet_leaf_0_clk _0865_ VGND VGND VPWR VPWR lsu.load_fifo.data_in\[18\] sky130_fd_sc_hd__dfxtp_1
X_4739_ clknet_leaf_61_clk _0796_ _0053_ VGND VGND VPWR VPWR lsu.current_store_addr\[7\]
+ sky130_fd_sc_hd__dfrtp_1
XFILLER_102_6 VPWR VGND VPWR VGND sky130_ef_sc_hd__decap_12
XFILLER_0_113 VPWR VGND VPWR VGND sky130_ef_sc_hd__decap_12
XFILLER_95_15 VPWR VGND VPWR VGND sky130_ef_sc_hd__decap_12
XFILLER_88_253 VPWR VGND VPWR VGND sky130_ef_sc_hd__decap_12
XFILLER_76_426 VGND VGND VPWR VPWR sky130_fd_sc_hd__fill_2
XFILLER_0_146 VPWR VGND VPWR VGND sky130_ef_sc_hd__decap_12
XFILLER_48_117 VGND VGND VPWR VPWR sky130_fd_sc_hd__fill_1
XFILLER_49_629 VGND VGND VPWR VPWR sky130_fd_sc_hd__fill_1
XFILLER_88_297 VGND VGND VPWR VPWR sky130_fd_sc_hd__fill_1
XFILLER_76_448 VPWR VGND VPWR VGND sky130_ef_sc_hd__decap_12
XFILLER_91_418 VGND VGND VPWR VPWR sky130_fd_sc_hd__fill_1
XTAP_TAPCELL_ROW_106_1405 VGND VPWR sky130_fd_sc_hd__tapvpwrvgnd_1
XFILLER_84_492 VGND VGND VPWR VPWR sky130_fd_sc_hd__decap_8
XFILLER_29_375 VGND VGND VPWR VPWR sky130_fd_sc_hd__fill_1
XFILLER_17_559 VGND VGND VPWR VPWR sky130_fd_sc_hd__fill_1
XTAP_TAPCELL_ROW_27_532 VGND VPWR sky130_fd_sc_hd__tapvpwrvgnd_1
XFILLER_44_345 VGND VGND VPWR VPWR sky130_fd_sc_hd__decap_8
XTAP_TAPCELL_ROW_55_830 VGND VPWR sky130_fd_sc_hd__tapvpwrvgnd_1
XFILLER_25_570 VGND VGND VPWR VPWR sky130_fd_sc_hd__fill_1
XFILLER_32_507 VGND VGND VPWR VPWR sky130_fd_sc_hd__decap_6
XFILLER_32_529 VGND VGND VPWR VPWR sky130_fd_sc_hd__decap_3
XFILLER_44_63 VGND VGND VPWR VPWR sky130_fd_sc_hd__decap_4
XFILLER_44_85 VGND VGND VPWR VPWR sky130_fd_sc_hd__fill_1
XFILLER_12_253 VGND VGND VPWR VPWR sky130_fd_sc_hd__fill_2
XFILLER_60_40 VGND VGND VPWR VPWR sky130_fd_sc_hd__decap_6
XFILLER_5_57 VPWR VGND VPWR VGND sky130_ef_sc_hd__decap_12
X_3070_ net710 net295 net208 VGND VGND VPWR VPWR _0575_ sky130_fd_sc_hd__mux2_1
XFILLER_94_245 VGND VGND VPWR VPWR sky130_fd_sc_hd__decap_6
XFILLER_82_418 VGND VGND VPWR VPWR sky130_fd_sc_hd__fill_2
XFILLER_94_289 VPWR VGND VPWR VGND sky130_ef_sc_hd__decap_12
XFILLER_35_356 VGND VGND VPWR VPWR sky130_fd_sc_hd__fill_2
XFILLER_16_581 VGND VGND VPWR VPWR sky130_fd_sc_hd__decap_6
XFILLER_50_348 VGND VGND VPWR VPWR sky130_fd_sc_hd__fill_2
X_3972_ lsu.load_fifo.queue\[8\]\[4\] lsu.load_fifo.queue\[9\]\[4\] lsu.load_fifo.queue\[10\]\[4\]
+ lsu.load_fifo.queue\[11\]\[4\] net391 net374 VGND VGND VPWR VPWR _1417_ sky130_fd_sc_hd__mux4_1
XFILLER_62_197 VGND VGND VPWR VPWR sky130_fd_sc_hd__decap_6
X_2923_ net948 net318 net218 VGND VGND VPWR VPWR _0435_ sky130_fd_sc_hd__mux2_1
XFILLER_31_540 VGND VGND VPWR VPWR sky130_fd_sc_hd__fill_1
X_2854_ net1048 net326 net222 VGND VGND VPWR VPWR _0365_ sky130_fd_sc_hd__mux2_1
XTAP_TAPCELL_ROW_61_899 VGND VPWR sky130_fd_sc_hd__tapvpwrvgnd_1
X_2785_ net1084 net288 _2031_ VGND VGND VPWR VPWR _0300_ sky130_fd_sc_hd__mux2_1
Xhold202 lsu.load_fifo.queue\[8\]\[20\] VGND VGND VPWR VPWR net670 sky130_fd_sc_hd__dlygate4sd3_1
X_4524_ clknet_leaf_5_clk _0581_ VGND VGND VPWR VPWR lsu.load_fifo.queue\[1\]\[4\]
+ sky130_fd_sc_hd__dfxtp_1
Xhold213 lsu.load_fifo.queue\[8\]\[0\] VGND VGND VPWR VPWR net681 sky130_fd_sc_hd__dlygate4sd3_1
Xhold224 lsu.store_fifo.queue\[10\]\[9\] VGND VGND VPWR VPWR net692 sky130_fd_sc_hd__dlygate4sd3_1
Xhold235 net147 VGND VGND VPWR VPWR net703 sky130_fd_sc_hd__dlygate4sd3_1
XTAP_TAPCELL_ROW_92_1239 VGND VPWR sky130_fd_sc_hd__tapvpwrvgnd_1
Xhold257 lsu.load_fifo.queue\[0\]\[9\] VGND VGND VPWR VPWR net725 sky130_fd_sc_hd__dlygate4sd3_1
X_4455_ clknet_leaf_79_clk _0512_ VGND VGND VPWR VPWR lsu.load_fifo.queue\[4\]\[31\]
+ sky130_fd_sc_hd__dfxtp_1
Xhold246 lsu.store_fifo.queue\[9\]\[9\] VGND VGND VPWR VPWR net714 sky130_fd_sc_hd__dlygate4sd3_1
Xhold268 lsu.store_fifo.queue\[0\]\[0\] VGND VGND VPWR VPWR net736 sky130_fd_sc_hd__dlygate4sd3_1
Xhold279 lsu.load_fifo.queue\[4\]\[16\] VGND VGND VPWR VPWR net747 sky130_fd_sc_hd__dlygate4sd3_1
X_3406_ net839 net310 net199 VGND VGND VPWR VPWR _1056_ sky130_fd_sc_hd__mux2_1
X_4386_ clknet_leaf_6_clk _0443_ VGND VGND VPWR VPWR lsu.load_fifo.queue\[6\]\[26\]
+ sky130_fd_sc_hd__dfxtp_1
X_3337_ net702 net317 net173 VGND VGND VPWR VPWR _0947_ sky130_fd_sc_hd__mux2_1
XFILLER_85_223 VGND VGND VPWR VPWR sky130_fd_sc_hd__fill_1
X_3268_ lsu.current_store_addr\[17\] net699 net258 VGND VGND VPWR VPWR _0828_ sky130_fd_sc_hd__mux2_1
XTAP_TAPCELL_ROW_69_988 VGND VPWR sky130_fd_sc_hd__tapvpwrvgnd_1
XFILLER_100_589 VPWR VGND VPWR VGND sky130_ef_sc_hd__decap_12
X_2219_ _1102_ _1671_ VGND VGND VPWR VPWR _1697_ sky130_fd_sc_hd__and2_1
X_3199_ net1031 net301 net203 VGND VGND VPWR VPWR _0700_ sky130_fd_sc_hd__mux2_1
XFILLER_26_301 VGND VGND VPWR VPWR sky130_fd_sc_hd__decap_6
X_5007_ clknet_leaf_16_clk _1062_ VGND VGND VPWR VPWR lsu.load_fifo.queue\[14\]\[28\]
+ sky130_fd_sc_hd__dfxtp_1
XFILLER_81_462 VGND VGND VPWR VPWR sky130_fd_sc_hd__decap_3
XTAP_TAPCELL_ROW_52_800 VGND VPWR sky130_fd_sc_hd__tapvpwrvgnd_1
XTAP_TAPCELL_ROW_101_1346 VGND VPWR sky130_fd_sc_hd__tapvpwrvgnd_1
XFILLER_14_77 VGND VGND VPWR VPWR sky130_fd_sc_hd__decap_6
XPHY_EDGE_ROW_15_Left_122 VGND VGND VPWR VPWR sky130_fd_sc_hd__decap_3
Xhold780 net158 VGND VGND VPWR VPWR net1248 sky130_fd_sc_hd__dlygate4sd3_1
Xhold791 acc.byte0\[6\] VGND VGND VPWR VPWR net1259 sky130_fd_sc_hd__dlygate4sd3_1
XFILLER_76_234 VGND VGND VPWR VPWR sky130_fd_sc_hd__fill_1
XTAP_TAPCELL_ROW_4_271 VGND VPWR sky130_fd_sc_hd__tapvpwrvgnd_1
XPHY_EDGE_ROW_24_Left_131 VGND VGND VPWR VPWR sky130_fd_sc_hd__decap_3
XFILLER_91_237 VPWR VGND VPWR VGND sky130_ef_sc_hd__decap_12
XTAP_TAPCELL_ROW_80_1110 VGND VPWR sky130_fd_sc_hd__tapvpwrvgnd_1
XFILLER_32_337 VGND VGND VPWR VPWR sky130_fd_sc_hd__fill_2
XFILLER_13_573 VPWR VGND VPWR VGND sky130_ef_sc_hd__decap_12
XPHY_EDGE_ROW_33_Left_140 VGND VGND VPWR VPWR sky130_fd_sc_hd__decap_3
X_2570_ lsu.current_load_addr\[10\] _1925_ net260 VGND VGND VPWR VPWR _1965_ sky130_fd_sc_hd__a21oi_1
XTAP_TAPCELL_ROW_78_1083 VGND VPWR sky130_fd_sc_hd__tapvpwrvgnd_1
XFILLER_99_337 VGND VGND VPWR VPWR sky130_fd_sc_hd__decap_4
X_4240_ clknet_leaf_56_clk _0297_ VGND VGND VPWR VPWR lsu.store_fifo.queue\[3\]\[8\]
+ sky130_fd_sc_hd__dfxtp_1
X_4171_ clknet_leaf_76_clk _0228_ VGND VGND VPWR VPWR lsu.load_fifo.queue\[11\]\[31\]
+ sky130_fd_sc_hd__dfxtp_1
X_3122_ net919 net322 net184 VGND VGND VPWR VPWR _0625_ sky130_fd_sc_hd__mux2_1
X_3053_ net885 net329 net206 VGND VGND VPWR VPWR _0558_ sky130_fd_sc_hd__mux2_1
XTAP_TAPCELL_ROW_66_958 VGND VPWR sky130_fd_sc_hd__tapvpwrvgnd_1
XFILLER_35_131 VGND VGND VPWR VPWR sky130_fd_sc_hd__decap_4
XTAP_TAPCELL_ROW_38_649 VGND VPWR sky130_fd_sc_hd__tapvpwrvgnd_1
XFILLER_50_123 VGND VGND VPWR VPWR sky130_fd_sc_hd__fill_1
X_3955_ lsu.load_fifo.queue\[12\]\[6\] lsu.load_fifo.queue\[13\]\[6\] lsu.load_fifo.queue\[14\]\[6\]
+ lsu.load_fifo.queue\[15\]\[6\] net383 net366 VGND VGND VPWR VPWR _1402_ sky130_fd_sc_hd__mux4_1
X_2906_ net1089 net353 net218 VGND VGND VPWR VPWR _0418_ sky130_fd_sc_hd__mux2_1
X_3886_ lsu.load_fifo.queue\[12\]\[16\] lsu.load_fifo.queue\[13\]\[16\] lsu.load_fifo.queue\[14\]\[16\]
+ lsu.load_fifo.queue\[15\]\[16\] net396 net379 VGND VGND VPWR VPWR _1343_ sky130_fd_sc_hd__mux4_1
X_2837_ net292 net1118 net227 VGND VGND VPWR VPWR _0350_ sky130_fd_sc_hd__mux2_1
X_2768_ net888 net277 _2028_ VGND VGND VPWR VPWR _0286_ sky130_fd_sc_hd__mux2_1
X_4507_ clknet_leaf_8_clk _0564_ VGND VGND VPWR VPWR lsu.load_fifo.queue\[2\]\[19\]
+ sky130_fd_sc_hd__dfxtp_1
X_2699_ net767 net302 net232 VGND VGND VPWR VPWR _0223_ sky130_fd_sc_hd__mux2_1
X_4438_ clknet_leaf_3_clk _0495_ VGND VGND VPWR VPWR lsu.load_fifo.queue\[4\]\[14\]
+ sky130_fd_sc_hd__dfxtp_1
X_4369_ clknet_leaf_82_clk _0426_ VGND VGND VPWR VPWR lsu.load_fifo.queue\[6\]\[9\]
+ sky130_fd_sc_hd__dfxtp_1
XFILLER_58_234 VGND VGND VPWR VPWR sky130_fd_sc_hd__fill_2
XFILLER_92_27 VGND VGND VPWR VPWR sky130_fd_sc_hd__fill_1
XTAP_TAPCELL_ROW_1_241 VGND VPWR sky130_fd_sc_hd__tapvpwrvgnd_1
XFILLER_42_613 VGND VGND VPWR VPWR sky130_fd_sc_hd__fill_2
XFILLER_54_451 VGND VGND VPWR VPWR sky130_fd_sc_hd__fill_1
XFILLER_81_281 VGND VGND VPWR VPWR sky130_fd_sc_hd__decap_4
XFILLER_42_624 VGND VGND VPWR VPWR sky130_fd_sc_hd__fill_2
XFILLER_10_587 VGND VGND VPWR VPWR sky130_fd_sc_hd__fill_1
XFILLER_6_525 VGND VGND VPWR VPWR sky130_fd_sc_hd__decap_6
XFILLER_6_569 VPWR VGND VPWR VGND sky130_ef_sc_hd__decap_12
XTAP_TAPCELL_ROW_9_330 VGND VPWR sky130_fd_sc_hd__tapvpwrvgnd_1
XFILLER_96_307 VGND VGND VPWR VPWR sky130_fd_sc_hd__fill_1
XFILLER_66_83 VGND VGND VPWR VPWR sky130_fd_sc_hd__fill_1
XTAP_TAPCELL_ROW_35_619 VGND VPWR sky130_fd_sc_hd__tapvpwrvgnd_1
XTAP_TAPCELL_ROW_63_928 VGND VPWR sky130_fd_sc_hd__tapvpwrvgnd_1
XFILLER_32_123 VGND VGND VPWR VPWR sky130_fd_sc_hd__decap_4
XFILLER_60_421 VGND VGND VPWR VPWR sky130_fd_sc_hd__decap_4
X_3740_ _1219_ _1220_ _1212_ VGND VGND VPWR VPWR _1222_ sky130_fd_sc_hd__a21o_1
XTAP_TAPCELL_ROW_15_398 VGND VPWR sky130_fd_sc_hd__tapvpwrvgnd_1
X_3671_ _1134_ _1152_ _1133_ VGND VGND VPWR VPWR _1153_ sky130_fd_sc_hd__a21boi_2
X_2622_ net196 _2001_ VGND VGND VPWR VPWR _0712_ sky130_fd_sc_hd__or2_1
XFILLER_63_3 VGND VGND VPWR VPWR sky130_fd_sc_hd__decap_6
Xoutput104 net104 VGND VGND VPWR VPWR load_addr[0] sky130_fd_sc_hd__buf_2
Xoutput115 net115 VGND VGND VPWR VPWR load_addr[1] sky130_fd_sc_hd__buf_2
X_2553_ lsu.current_load_addr\[13\] lsu.current_load_addr\[12\] _1926_ lsu.current_load_addr\[14\]
+ VGND VGND VPWR VPWR _1952_ sky130_fd_sc_hd__a31o_1
Xoutput126 net126 VGND VGND VPWR VPWR load_req sky130_fd_sc_hd__buf_2
Xoutput137 net137 VGND VGND VPWR VPWR store_addr[19] sky130_fd_sc_hd__buf_2
Xoutput159 net159 VGND VGND VPWR VPWR store_req sky130_fd_sc_hd__buf_2
Xoutput148 net148 VGND VGND VPWR VPWR store_addr[9] sky130_fd_sc_hd__buf_2
X_2484_ net1313 net238 _1902_ VGND VGND VPWR VPWR _0793_ sky130_fd_sc_hd__o21a_1
X_4223_ clknet_leaf_59_clk _0280_ VGND VGND VPWR VPWR lsu.store_fifo.queue\[4\]\[1\]
+ sky130_fd_sc_hd__dfxtp_1
X_4154_ clknet_leaf_3_clk _0211_ VGND VGND VPWR VPWR lsu.load_fifo.queue\[11\]\[14\]
+ sky130_fd_sc_hd__dfxtp_1
X_3105_ _2039_ _2041_ VGND VGND VPWR VPWR _2045_ sky130_fd_sc_hd__and2_2
XFILLER_68_587 VGND VGND VPWR VPWR sky130_fd_sc_hd__fill_1
X_4085_ lsu.store_fifo.queue\[0\]\[2\] lsu.store_fifo.queue\[1\]\[2\] lsu.store_fifo.queue\[2\]\[2\]
+ lsu.store_fifo.queue\[3\]\[2\] net411 net408 VGND VGND VPWR VPWR _1518_ sky130_fd_sc_hd__mux4_1
X_3036_ net631 net297 net212 VGND VGND VPWR VPWR _0542_ sky130_fd_sc_hd__mux2_1
XFILLER_102_26 VGND VGND VPWR VPWR sky130_fd_sc_hd__fill_2
XFILLER_24_613 VPWR VGND VPWR VGND sky130_ef_sc_hd__decap_12
XFILLER_51_421 VGND VGND VPWR VPWR sky130_fd_sc_hd__decap_6
XFILLER_63_270 VGND VGND VPWR VPWR sky130_fd_sc_hd__fill_1
XFILLER_63_281 VGND VGND VPWR VPWR sky130_fd_sc_hd__fill_1
XFILLER_51_465 VPWR VGND VPWR VGND sky130_ef_sc_hd__decap_12
X_4987_ clknet_leaf_33_clk _1042_ VGND VGND VPWR VPWR lsu.load_fifo.queue\[14\]\[8\]
+ sky130_fd_sc_hd__dfxtp_1
X_3938_ _1384_ _1387_ net357 VGND VGND VPWR VPWR _1388_ sky130_fd_sc_hd__mux2_1
X_3869_ lsu.load_fifo.queue\[8\]\[19\] lsu.load_fifo.queue\[9\]\[19\] lsu.load_fifo.queue\[10\]\[19\]
+ lsu.load_fifo.queue\[11\]\[19\] net389 net372 VGND VGND VPWR VPWR _1329_ sky130_fd_sc_hd__mux4_1
XFILLER_11_34 VGND VGND VPWR VPWR sky130_fd_sc_hd__decap_4
XFILLER_3_517 VPWR VGND VPWR VGND sky130_ef_sc_hd__decap_12
XFILLER_87_27 VPWR VGND VPWR VGND sky130_ef_sc_hd__decap_12
XFILLER_78_318 VGND VGND VPWR VPWR sky130_fd_sc_hd__decap_4
XTAP_TAPCELL_ROW_6_300 VGND VPWR sky130_fd_sc_hd__tapvpwrvgnd_1
Xfanout320 lsu.load_fifo.data_in\[17\] VGND VGND VPWR VPWR net320 sky130_fd_sc_hd__clkbuf_2
Xfanout331 lsu.load_fifo.data_in\[12\] VGND VGND VPWR VPWR net331 sky130_fd_sc_hd__dlymetal6s2s_1
Xfanout342 lsu.load_fifo.data_in\[6\] VGND VGND VPWR VPWR net342 sky130_fd_sc_hd__clkbuf_2
Xfanout353 lsu.load_fifo.data_in\[1\] VGND VGND VPWR VPWR net353 sky130_fd_sc_hd__dlymetal6s2s_1
Xfanout375 net382 VGND VGND VPWR VPWR net375 sky130_fd_sc_hd__buf_2
Xfanout364 net365 VGND VGND VPWR VPWR net364 sky130_fd_sc_hd__clkbuf_4
XFILLER_74_513 VPWR VGND VPWR VGND sky130_ef_sc_hd__decap_12
Xfanout397 net398 VGND VGND VPWR VPWR net397 sky130_fd_sc_hd__clkbuf_4
Xfanout386 net399 VGND VGND VPWR VPWR net386 sky130_fd_sc_hd__buf_2
XFILLER_46_204 VGND VGND VPWR VPWR sky130_fd_sc_hd__decap_6
XFILLER_100_194 VGND VGND VPWR VPWR sky130_fd_sc_hd__fill_2
XFILLER_100_183 VGND VGND VPWR VPWR sky130_fd_sc_hd__decap_4
XFILLER_46_237 VGND VGND VPWR VPWR sky130_fd_sc_hd__fill_1
XFILLER_52_41 VGND VGND VPWR VPWR sky130_fd_sc_hd__fill_2
XFILLER_52_85 VGND VGND VPWR VPWR sky130_fd_sc_hd__decap_4
Xinput28 load_base_addr[13] VGND VGND VPWR VPWR net28 sky130_fd_sc_hd__clkbuf_1
Xinput17 count[3] VGND VGND VPWR VPWR net17 sky130_fd_sc_hd__buf_1
XTAP_TAPCELL_ROW_12_357 VGND VPWR sky130_fd_sc_hd__tapvpwrvgnd_1
XTAP_TAPCELL_ROW_40_666 VGND VPWR sky130_fd_sc_hd__tapvpwrvgnd_1
Xinput39 load_base_addr[3] VGND VGND VPWR VPWR net39 sky130_fd_sc_hd__clkbuf_1
XTAP_TAPCELL_ROW_75_1053 VGND VPWR sky130_fd_sc_hd__tapvpwrvgnd_1
XFILLER_92_365 VGND VGND VPWR VPWR sky130_fd_sc_hd__decap_8
XTAP_TAPCELL_ROW_48_755 VGND VPWR sky130_fd_sc_hd__tapvpwrvgnd_1
XFILLER_93_81 VPWR VGND VPWR VGND sky130_ef_sc_hd__decap_12
XTAP_TAPCELL_ROW_86_1171 VGND VPWR sky130_fd_sc_hd__tapvpwrvgnd_1
X_4910_ clknet_leaf_4_clk _0965_ VGND VGND VPWR VPWR lsu.load_fifo.queue\[13\]\[5\]
+ sky130_fd_sc_hd__dfxtp_1
XFILLER_45_270 VGND VGND VPWR VPWR sky130_fd_sc_hd__decap_8
X_4841_ clknet_leaf_45_clk _0898_ _0091_ VGND VGND VPWR VPWR lsu.store_counter\[18\]
+ sky130_fd_sc_hd__dfrtp_2
XFILLER_33_432 VGND VGND VPWR VPWR sky130_fd_sc_hd__fill_1
XFILLER_33_465 VGND VGND VPWR VPWR sky130_fd_sc_hd__decap_3
XFILLER_33_476 VGND VGND VPWR VPWR sky130_fd_sc_hd__decap_4
X_4772_ clknet_leaf_44_clk net923 VGND VGND VPWR VPWR net136 sky130_fd_sc_hd__dfxtp_1
XFILLER_20_126 VGND VGND VPWR VPWR sky130_fd_sc_hd__decap_3
XFILLER_20_137 VGND VGND VPWR VPWR sky130_fd_sc_hd__decap_3
X_3723_ _1203_ _1204_ VGND VGND VPWR VPWR _1205_ sky130_fd_sc_hd__nand2b_1
X_3654_ acc.byte1\[4\] acc.byte0\[4\] VGND VGND VPWR VPWR _1136_ sky130_fd_sc_hd__and2_1
X_2605_ lsu.current_load_addr\[1\] _1990_ net476 VGND VGND VPWR VPWR _0728_ sky130_fd_sc_hd__mux2_4
X_3585_ net425 VGND VGND VPWR VPWR _0149_ sky130_fd_sc_hd__inv_2
X_2536_ net34 net262 _1931_ _1936_ VGND VGND VPWR VPWR _1940_ sky130_fd_sc_hd__a22o_1
X_2467_ lsu.current_store_addr\[9\] net238 _1890_ VGND VGND VPWR VPWR _0798_ sky130_fd_sc_hd__o21a_1
X_4206_ clknet_leaf_56_clk _0263_ VGND VGND VPWR VPWR lsu.store_fifo.queue\[6\]\[4\]
+ sky130_fd_sc_hd__dfxtp_1
X_2398_ net1251 _1836_ _1716_ VGND VGND VPWR VPWR _0835_ sky130_fd_sc_hd__o21a_1
XFILLER_95_181 VPWR VGND VPWR VGND sky130_ef_sc_hd__decap_12
X_4137_ clknet_leaf_66_clk _0194_ VGND VGND VPWR VPWR lsu.store_fifo.queue\[10\]\[7\]
+ sky130_fd_sc_hd__dfxtp_1
XFILLER_56_557 VPWR VGND VPWR VGND sky130_ef_sc_hd__decap_12
XFILLER_83_365 VGND VGND VPWR VPWR sky130_fd_sc_hd__decap_4
XFILLER_71_505 VPWR VGND VPWR VGND sky130_ef_sc_hd__decap_12
X_4068_ lsu.store_fifo.queue\[12\]\[4\] lsu.store_fifo.queue\[13\]\[4\] lsu.store_fifo.queue\[14\]\[4\]
+ lsu.store_fifo.queue\[15\]\[4\] net414 net410 VGND VGND VPWR VPWR _1503_ sky130_fd_sc_hd__mux4_1
X_3019_ net862 net331 net212 VGND VGND VPWR VPWR _0525_ sky130_fd_sc_hd__mux2_1
XFILLER_11_159 VGND VGND VPWR VPWR sky130_fd_sc_hd__fill_1
XFILLER_11_148 VGND VGND VPWR VPWR sky130_fd_sc_hd__fill_2
XFILLER_98_15 VPWR VGND VPWR VGND sky130_ef_sc_hd__decap_12
XFILLER_105_220 VGND VGND VPWR VPWR sky130_fd_sc_hd__fill_1
XFILLER_3_369 VPWR VGND VPWR VGND sky130_ef_sc_hd__decap_12
Xfanout161 _1666_ VGND VGND VPWR VPWR net161 sky130_fd_sc_hd__buf_8
Xfanout172 _2056_ VGND VGND VPWR VPWR net172 sky130_fd_sc_hd__buf_2
Xfanout183 _2045_ VGND VGND VPWR VPWR net183 sky130_fd_sc_hd__buf_4
XFILLER_101_492 VGND VGND VPWR VPWR sky130_fd_sc_hd__fill_2
Xfanout194 _2000_ VGND VGND VPWR VPWR net194 sky130_fd_sc_hd__buf_2
XTAP_TAPCELL_ROW_17_416 VGND VPWR sky130_fd_sc_hd__tapvpwrvgnd_1
XTAP_TAPCELL_ROW_45_725 VGND VPWR sky130_fd_sc_hd__tapvpwrvgnd_1
XFILLER_42_251 VGND VGND VPWR VPWR sky130_fd_sc_hd__fill_1
XPHY_EDGE_ROW_7_Left_114 VGND VGND VPWR VPWR sky130_fd_sc_hd__decap_3
XFILLER_10_192 VGND VGND VPWR VPWR sky130_fd_sc_hd__decap_4
XFILLER_6_141 VPWR VGND VPWR VGND sky130_ef_sc_hd__decap_12
Xhold609 lsu.load_fifo.queue\[13\]\[1\] VGND VGND VPWR VPWR net1077 sky130_fd_sc_hd__dlygate4sd3_1
X_3370_ net317 net1219 net169 VGND VGND VPWR VPWR _0979_ sky130_fd_sc_hd__mux2_1
XFILLER_97_402 VGND VGND VPWR VPWR sky130_fd_sc_hd__fill_1
X_2321_ _1765_ _1766_ VGND VGND VPWR VPWR _0883_ sky130_fd_sc_hd__and2_1
X_2252_ net79 _1716_ VGND VGND VPWR VPWR _1717_ sky130_fd_sc_hd__or2_1
X_5040_ clknet_leaf_64_clk _1095_ VGND VGND VPWR VPWR lsu.store_fifo.queue\[12\]\[9\]
+ sky130_fd_sc_hd__dfxtp_1
XTAP_TAPCELL_ROW_88_1200 VGND VPWR sky130_fd_sc_hd__tapvpwrvgnd_1
XFILLER_26_3 VGND VGND VPWR VPWR sky130_fd_sc_hd__decap_8
X_2183_ lsu.load_counter\[13\] lsu.load_counter\[12\] _1672_ VGND VGND VPWR VPWR _1673_
+ sky130_fd_sc_hd__and3_1
XFILLER_38_557 VGND VGND VPWR VPWR sky130_fd_sc_hd__decap_3
X_4824_ clknet_leaf_36_clk _0881_ _0074_ VGND VGND VPWR VPWR lsu.store_counter\[1\]
+ sky130_fd_sc_hd__dfrtp_1
X_4755_ clknet_leaf_44_clk net794 VGND VGND VPWR VPWR net138 sky130_fd_sc_hd__dfxtp_1
X_3706_ _1181_ _1186_ VGND VGND VPWR VPWR _1188_ sky130_fd_sc_hd__nand2_1
X_4686_ clknet_leaf_29_clk _0743_ _0032_ VGND VGND VPWR VPWR lsu.current_load_addr\[16\]
+ sky130_fd_sc_hd__dfrtp_1
X_3637_ net6 VGND VGND VPWR VPWR _1119_ sky130_fd_sc_hd__inv_2
X_3568_ net431 VGND VGND VPWR VPWR _0132_ sky130_fd_sc_hd__inv_2
X_2519_ lsu.current_load_addr\[9\] lsu.current_load_addr\[8\] lsu.current_load_addr\[7\]
+ _1923_ VGND VGND VPWR VPWR _1925_ sky130_fd_sc_hd__and4_2
XFILLER_88_413 VGND VGND VPWR VPWR sky130_fd_sc_hd__decap_6
XFILLER_68_29 VGND VGND VPWR VPWR sky130_fd_sc_hd__fill_2
XFILLER_0_317 VGND VGND VPWR VPWR sky130_fd_sc_hd__decap_8
XFILLER_0_328 VGND VGND VPWR VPWR sky130_fd_sc_hd__decap_8
XFILLER_88_446 VPWR VGND VPWR VGND sky130_ef_sc_hd__decap_12
XFILLER_88_435 VGND VGND VPWR VPWR sky130_fd_sc_hd__decap_4
X_3499_ net441 VGND VGND VPWR VPWR _0063_ sky130_fd_sc_hd__inv_2
XFILLER_75_129 VGND VGND VPWR VPWR sky130_fd_sc_hd__fill_2
Xclone2 net7 net6 _1561_ net5 VGND VGND VPWR VPWR net470 sky130_fd_sc_hd__or4_1
XFILLER_17_55 VGND VGND VPWR VPWR sky130_fd_sc_hd__fill_1
XFILLER_52_571 VPWR VGND VPWR VGND sky130_ef_sc_hd__decap_12
XTAP_TAPCELL_ROW_104_1377 VGND VPWR sky130_fd_sc_hd__tapvpwrvgnd_1
XFILLER_12_457 VPWR VGND VPWR VGND sky130_ef_sc_hd__decap_12
XTAP_TAPCELL_ROW_22_474 VGND VPWR sky130_fd_sc_hd__tapvpwrvgnd_1
XTAP_TAPCELL_ROW_50_783 VGND VPWR sky130_fd_sc_hd__tapvpwrvgnd_1
XFILLER_4_601 VPWR VGND VPWR VGND sky130_ef_sc_hd__decap_12
XPHY_EDGE_ROW_89_Left_196 VGND VGND VPWR VPWR sky130_fd_sc_hd__decap_3
XTAP_TAPCELL_ROW_72_1023 VGND VPWR sky130_fd_sc_hd__tapvpwrvgnd_1
XFILLER_106_595 VPWR VGND VPWR VGND sky130_ef_sc_hd__decap_12
XFILLER_94_449 VPWR VGND VPWR VGND sky130_ef_sc_hd__decap_12
Xclkbuf_leaf_86_clk clknet_3_0__leaf_clk VGND VGND VPWR VPWR clknet_leaf_86_clk sky130_fd_sc_hd__clkbuf_8
XFILLER_47_321 VGND VGND VPWR VPWR sky130_fd_sc_hd__decap_6
XFILLER_47_332 VGND VGND VPWR VPWR sky130_fd_sc_hd__decap_4
XTAP_TAPCELL_ROW_58_872 VGND VPWR sky130_fd_sc_hd__tapvpwrvgnd_1
XTAP_TAPCELL_ROW_83_1141 VGND VPWR sky130_fd_sc_hd__tapvpwrvgnd_1
XFILLER_50_508 VPWR VGND VPWR VGND sky130_ef_sc_hd__decap_12
X_2870_ net574 net295 net225 VGND VGND VPWR VPWR _0381_ sky130_fd_sc_hd__mux2_1
X_4540_ clknet_leaf_83_clk _0597_ VGND VGND VPWR VPWR lsu.load_fifo.queue\[1\]\[20\]
+ sky130_fd_sc_hd__dfxtp_1
Xclkbuf_leaf_10_clk clknet_3_1__leaf_clk VGND VGND VPWR VPWR clknet_leaf_10_clk sky130_fd_sc_hd__clkbuf_8
Xhold406 lsu.load_fifo.queue\[0\]\[6\] VGND VGND VPWR VPWR net874 sky130_fd_sc_hd__dlygate4sd3_1
XFILLER_7_461 VPWR VGND VPWR VGND sky130_ef_sc_hd__decap_12
Xhold417 lsu.load_fifo.queue\[2\]\[13\] VGND VGND VPWR VPWR net885 sky130_fd_sc_hd__dlygate4sd3_1
X_4471_ clknet_leaf_11_clk _0528_ VGND VGND VPWR VPWR lsu.load_fifo.queue\[3\]\[15\]
+ sky130_fd_sc_hd__dfxtp_1
Xhold428 lsu.store_fifo.queue\[10\]\[7\] VGND VGND VPWR VPWR net896 sky130_fd_sc_hd__dlygate4sd3_1
Xhold439 lsu.load_fifo.queue\[14\]\[1\] VGND VGND VPWR VPWR net907 sky130_fd_sc_hd__dlygate4sd3_1
X_3422_ net280 net724 _2058_ VGND VGND VPWR VPWR _1071_ sky130_fd_sc_hd__mux2_1
X_3353_ net350 net1058 net171 VGND VGND VPWR VPWR _0962_ sky130_fd_sc_hd__mux2_1
X_3284_ net428 _1549_ VGND VGND VPWR VPWR _2054_ sky130_fd_sc_hd__nor2_4
X_2304_ lsu.store_counter\[10\] _1755_ _1756_ _1729_ VGND VGND VPWR VPWR _0890_ sky130_fd_sc_hd__a22o_1
X_2235_ _1105_ _1705_ _1706_ net483 VGND VGND VPWR VPWR _0909_ sky130_fd_sc_hd__a2bb2o_1
Xclkbuf_leaf_77_clk clknet_3_1__leaf_clk VGND VGND VPWR VPWR clknet_leaf_77_clk sky130_fd_sc_hd__clkbuf_8
X_5023_ clknet_leaf_55_clk _1078_ _0167_ VGND VGND VPWR VPWR acc.data_out\[2\] sky130_fd_sc_hd__dfrtp_1
X_2166_ lsu.load_counter\[0\] net2 VGND VGND VPWR VPWR _1656_ sky130_fd_sc_hd__or2_1
XFILLER_38_365 VGND VGND VPWR VPWR sky130_fd_sc_hd__decap_8
XFILLER_38_398 VGND VGND VPWR VPWR sky130_fd_sc_hd__fill_1
X_2097_ _1119_ _1120_ _1560_ _1118_ VGND VGND VPWR VPWR _1587_ sky130_fd_sc_hd__a31o_1
X_4807_ clknet_leaf_81_clk _0864_ VGND VGND VPWR VPWR lsu.load_fifo.data_in\[17\]
+ sky130_fd_sc_hd__dfxtp_1
XPHY_EDGE_ROW_3_Right_3 VGND VGND VPWR VPWR sky130_fd_sc_hd__decap_3
XFILLER_21_276 VGND VGND VPWR VPWR sky130_fd_sc_hd__decap_4
X_2999_ net899 net302 net191 VGND VGND VPWR VPWR _0507_ sky130_fd_sc_hd__mux2_1
X_4738_ clknet_leaf_48_clk _0795_ _0052_ VGND VGND VPWR VPWR lsu.current_store_addr\[6\]
+ sky130_fd_sc_hd__dfrtp_2
X_4669_ clknet_leaf_65_clk _0726_ VGND VGND VPWR VPWR lsu.store_fifo.queue\[15\]\[9\]
+ sky130_fd_sc_hd__dfxtp_1
XFILLER_1_615 VGND VGND VPWR VPWR sky130_fd_sc_hd__fill_1
XFILLER_0_125 VPWR VGND VPWR VGND sky130_ef_sc_hd__decap_12
XFILLER_95_27 VPWR VGND VPWR VGND sky130_ef_sc_hd__decap_12
XFILLER_88_265 VPWR VGND VPWR VGND sky130_ef_sc_hd__decap_12
XFILLER_0_169 VPWR VGND VPWR VGND sky130_ef_sc_hd__decap_12
XFILLER_0_158 VGND VGND VPWR VPWR sky130_fd_sc_hd__decap_8
XFILLER_103_587 VPWR VGND VPWR VGND sky130_ef_sc_hd__decap_12
Xclkbuf_leaf_68_clk clknet_3_4__leaf_clk VGND VGND VPWR VPWR clknet_leaf_68_clk sky130_fd_sc_hd__clkbuf_8
XFILLER_28_65 VGND VGND VPWR VPWR sky130_fd_sc_hd__fill_1
XTAP_TAPCELL_ROW_106_1406 VGND VPWR sky130_fd_sc_hd__tapvpwrvgnd_1
XFILLER_17_505 VPWR VGND VPWR VGND sky130_ef_sc_hd__decap_12
XTAP_TAPCELL_ROW_27_522 VGND VPWR sky130_fd_sc_hd__tapvpwrvgnd_1
XFILLER_44_357 VGND VGND VPWR VPWR sky130_fd_sc_hd__decap_6
XTAP_TAPCELL_ROW_55_831 VGND VPWR sky130_fd_sc_hd__tapvpwrvgnd_1
XFILLER_71_165 VGND VGND VPWR VPWR sky130_fd_sc_hd__decap_3
XFILLER_44_75 VGND VGND VPWR VPWR sky130_fd_sc_hd__decap_8
XFILLER_60_63 VGND VGND VPWR VPWR sky130_fd_sc_hd__decap_4
XPHY_EDGE_ROW_97_Left_204 VGND VGND VPWR VPWR sky130_fd_sc_hd__decap_3
XFILLER_60_85 VGND VGND VPWR VPWR sky130_fd_sc_hd__decap_3
XFILLER_5_69 VPWR VGND VPWR VGND sky130_ef_sc_hd__decap_12
XFILLER_4_475 VGND VGND VPWR VPWR sky130_fd_sc_hd__fill_1
XFILLER_67_449 VGND VGND VPWR VPWR sky130_fd_sc_hd__fill_2
Xclkbuf_leaf_59_clk clknet_3_5__leaf_clk VGND VGND VPWR VPWR clknet_leaf_59_clk sky130_fd_sc_hd__clkbuf_8
XFILLER_47_184 VGND VGND VPWR VPWR sky130_fd_sc_hd__fill_1
X_3971_ lsu.load_fifo.queue\[12\]\[4\] lsu.load_fifo.queue\[13\]\[4\] lsu.load_fifo.queue\[14\]\[4\]
+ lsu.load_fifo.queue\[15\]\[4\] net391 net374 VGND VGND VPWR VPWR _1416_ sky130_fd_sc_hd__mux4_1
X_2922_ net976 net320 net219 VGND VGND VPWR VPWR _0434_ sky130_fd_sc_hd__mux2_1
XFILLER_93_3 VPWR VGND VPWR VGND sky130_ef_sc_hd__decap_12
XFILLER_43_390 VGND VGND VPWR VPWR sky130_fd_sc_hd__fill_2
X_2853_ net715 net329 net222 VGND VGND VPWR VPWR _0364_ sky130_fd_sc_hd__mux2_1
X_2784_ net505 net290 _2031_ VGND VGND VPWR VPWR _0299_ sky130_fd_sc_hd__mux2_1
X_4523_ clknet_leaf_86_clk _0580_ VGND VGND VPWR VPWR lsu.load_fifo.queue\[1\]\[3\]
+ sky130_fd_sc_hd__dfxtp_1
Xhold214 lsu.load_fifo.queue\[8\]\[1\] VGND VGND VPWR VPWR net682 sky130_fd_sc_hd__dlygate4sd3_1
Xhold203 lsu.load_fifo.queue\[3\]\[26\] VGND VGND VPWR VPWR net671 sky130_fd_sc_hd__dlygate4sd3_1
Xhold225 lsu.store_fifo.queue\[14\]\[6\] VGND VGND VPWR VPWR net693 sky130_fd_sc_hd__dlygate4sd3_1
Xhold269 lsu.load_fifo.queue\[3\]\[27\] VGND VGND VPWR VPWR net737 sky130_fd_sc_hd__dlygate4sd3_1
Xhold258 lsu.load_fifo.queue\[2\]\[3\] VGND VGND VPWR VPWR net726 sky130_fd_sc_hd__dlygate4sd3_1
Xhold247 lsu.load_fifo.queue\[10\]\[13\] VGND VGND VPWR VPWR net715 sky130_fd_sc_hd__dlygate4sd3_1
Xhold236 _0819_ VGND VGND VPWR VPWR net704 sky130_fd_sc_hd__dlygate4sd3_1
X_4454_ clknet_leaf_11_clk _0511_ VGND VGND VPWR VPWR lsu.load_fifo.queue\[4\]\[30\]
+ sky130_fd_sc_hd__dfxtp_1
X_3405_ net1138 net313 net200 VGND VGND VPWR VPWR _1055_ sky130_fd_sc_hd__mux2_1
X_4385_ clknet_leaf_68_clk _0442_ VGND VGND VPWR VPWR lsu.load_fifo.queue\[6\]\[25\]
+ sky130_fd_sc_hd__dfxtp_1
X_3336_ net1185 net318 net173 VGND VGND VPWR VPWR _0946_ sky130_fd_sc_hd__mux2_1
XFILLER_85_202 VGND VGND VPWR VPWR sky130_fd_sc_hd__decap_4
X_3267_ lsu.current_store_addr\[16\] net825 net258 VGND VGND VPWR VPWR _0827_ sky130_fd_sc_hd__mux2_1
X_5006_ clknet_leaf_83_clk _1061_ VGND VGND VPWR VPWR lsu.load_fifo.queue\[14\]\[27\]
+ sky130_fd_sc_hd__dfxtp_1
X_2218_ net166 net163 _1671_ net263 net243 VGND VGND VPWR VPWR _1696_ sky130_fd_sc_hd__o221a_1
XTAP_TAPCELL_ROW_69_989 VGND VPWR sky130_fd_sc_hd__tapvpwrvgnd_1
X_3198_ net1075 net303 net204 VGND VGND VPWR VPWR _0699_ sky130_fd_sc_hd__mux2_1
X_2149_ _1552_ _1638_ VGND VGND VPWR VPWR _1639_ sky130_fd_sc_hd__nor2_1
XFILLER_53_132 VGND VGND VPWR VPWR sky130_fd_sc_hd__decap_6
XTAP_TAPCELL_ROW_52_801 VGND VPWR sky130_fd_sc_hd__tapvpwrvgnd_1
XFILLER_81_496 VGND VGND VPWR VPWR sky130_fd_sc_hd__fill_1
XTAP_TAPCELL_ROW_101_1336 VGND VPWR sky130_fd_sc_hd__tapvpwrvgnd_1
XFILLER_22_530 VGND VGND VPWR VPWR sky130_fd_sc_hd__fill_2
XTAP_TAPCELL_ROW_32_580 VGND VPWR sky130_fd_sc_hd__tapvpwrvgnd_1
XFILLER_30_11 VGND VGND VPWR VPWR sky130_fd_sc_hd__fill_1
Xhold781 lsu.load_fifo.data_in\[0\] VGND VGND VPWR VPWR net1249 sky130_fd_sc_hd__dlygate4sd3_1
XFILLER_89_541 VGND VGND VPWR VPWR sky130_fd_sc_hd__decap_6
Xhold770 net149 VGND VGND VPWR VPWR net1238 sky130_fd_sc_hd__dlygate4sd3_1
XFILLER_49_405 VGND VGND VPWR VPWR sky130_fd_sc_hd__decap_4
Xhold792 acc.byte0\[4\] VGND VGND VPWR VPWR net1260 sky130_fd_sc_hd__dlygate4sd3_1
XFILLER_76_257 VGND VGND VPWR VPWR sky130_fd_sc_hd__fill_1
XFILLER_91_205 VPWR VGND VPWR VGND sky130_ef_sc_hd__decap_12
XTAP_TAPCELL_ROW_4_272 VGND VPWR sky130_fd_sc_hd__tapvpwrvgnd_1
XFILLER_91_249 VPWR VGND VPWR VGND sky130_ef_sc_hd__decap_12
XTAP_TAPCELL_ROW_80_1111 VGND VPWR sky130_fd_sc_hd__tapvpwrvgnd_1
XFILLER_13_541 VPWR VGND VPWR VGND sky130_ef_sc_hd__decap_12
XFILLER_13_585 VPWR VGND VPWR VGND sky130_ef_sc_hd__decap_12
XFILLER_99_305 VGND VGND VPWR VPWR sky130_fd_sc_hd__decap_8
XTAP_TAPCELL_ROW_78_1084 VGND VPWR sky130_fd_sc_hd__tapvpwrvgnd_1
X_4170_ clknet_leaf_12_clk _0227_ VGND VGND VPWR VPWR lsu.load_fifo.queue\[11\]\[30\]
+ sky130_fd_sc_hd__dfxtp_1
X_3121_ net956 net325 net184 VGND VGND VPWR VPWR _0624_ sky130_fd_sc_hd__mux2_1
XFILLER_82_205 VGND VGND VPWR VPWR sky130_fd_sc_hd__decap_8
X_3052_ net569 net330 net208 VGND VGND VPWR VPWR _0557_ sky130_fd_sc_hd__mux2_1
XTAP_TAPCELL_ROW_66_959 VGND VPWR sky130_fd_sc_hd__tapvpwrvgnd_1
X_3954_ lsu.load_fifo.queue\[8\]\[6\] lsu.load_fifo.queue\[9\]\[6\] lsu.load_fifo.queue\[10\]\[6\]
+ lsu.load_fifo.queue\[11\]\[6\] net383 net366 VGND VGND VPWR VPWR _1401_ sky130_fd_sc_hd__mux4_1
X_3885_ lsu.load_fifo.queue\[0\]\[16\] lsu.load_fifo.queue\[1\]\[16\] lsu.load_fifo.queue\[2\]\[16\]
+ lsu.load_fifo.queue\[3\]\[16\] net396 net379 VGND VGND VPWR VPWR _1342_ sky130_fd_sc_hd__mux4_1
X_2905_ net915 net354 net221 VGND VGND VPWR VPWR _0417_ sky130_fd_sc_hd__mux2_1
X_2836_ net295 net1180 net229 VGND VGND VPWR VPWR _0349_ sky130_fd_sc_hd__mux2_1
X_2767_ net531 net279 _2028_ VGND VGND VPWR VPWR _0285_ sky130_fd_sc_hd__mux2_1
X_2698_ net838 net304 net231 VGND VGND VPWR VPWR _0222_ sky130_fd_sc_hd__mux2_1
X_4506_ clknet_leaf_2_clk _0563_ VGND VGND VPWR VPWR lsu.load_fifo.queue\[2\]\[18\]
+ sky130_fd_sc_hd__dfxtp_1
X_4437_ clknet_leaf_4_clk _0494_ VGND VGND VPWR VPWR lsu.load_fifo.queue\[4\]\[13\]
+ sky130_fd_sc_hd__dfxtp_1
XFILLER_98_393 VGND VGND VPWR VPWR sky130_fd_sc_hd__fill_1
XFILLER_86_533 VPWR VGND VPWR VGND sky130_ef_sc_hd__decap_12
XFILLER_76_29 VGND VGND VPWR VPWR sky130_fd_sc_hd__decap_4
XFILLER_76_18 VGND VGND VPWR VPWR sky130_fd_sc_hd__fill_2
X_4368_ clknet_leaf_11_clk _0425_ VGND VGND VPWR VPWR lsu.load_fifo.queue\[6\]\[8\]
+ sky130_fd_sc_hd__dfxtp_1
XFILLER_86_566 VPWR VGND VPWR VGND sky130_ef_sc_hd__decap_12
X_3319_ net865 net352 net173 VGND VGND VPWR VPWR _0929_ sky130_fd_sc_hd__mux2_1
X_4299_ clknet_leaf_5_clk _0356_ VGND VGND VPWR VPWR lsu.load_fifo.queue\[10\]\[5\]
+ sky130_fd_sc_hd__dfxtp_1
XFILLER_100_376 VGND VGND VPWR VPWR sky130_fd_sc_hd__fill_2
XFILLER_100_365 VGND VGND VPWR VPWR sky130_fd_sc_hd__decap_3
XTAP_TAPCELL_ROW_1_242 VGND VPWR sky130_fd_sc_hd__tapvpwrvgnd_1
XFILLER_10_533 VPWR VGND VPWR VGND sky130_ef_sc_hd__decap_12
XTAP_TAPCELL_ROW_9_331 VGND VPWR sky130_fd_sc_hd__tapvpwrvgnd_1
XFILLER_1_220 VGND VGND VPWR VPWR sky130_fd_sc_hd__decap_4
XFILLER_2_15 VPWR VGND VPWR VGND sky130_ef_sc_hd__decap_12
XFILLER_89_393 VPWR VGND VPWR VGND sky130_ef_sc_hd__decap_12
XTAP_TAPCELL_ROW_63_918 VGND VPWR sky130_fd_sc_hd__tapvpwrvgnd_1
XFILLER_32_102 VGND VGND VPWR VPWR sky130_fd_sc_hd__fill_1
XFILLER_82_83 VGND VGND VPWR VPWR sky130_fd_sc_hd__fill_1
XTAP_TAPCELL_ROW_15_399 VGND VPWR sky130_fd_sc_hd__tapvpwrvgnd_1
XFILLER_13_393 VPWR VGND VPWR VGND sky130_ef_sc_hd__decap_12
X_3670_ _1149_ _1150_ _1136_ VGND VGND VPWR VPWR _1152_ sky130_fd_sc_hd__a21o_1
X_2621_ net416 _1999_ VGND VGND VPWR VPWR _2001_ sky130_fd_sc_hd__and2_1
Xoutput116 net116 VGND VGND VPWR VPWR load_addr[20] sky130_fd_sc_hd__buf_2
Xoutput105 net105 VGND VGND VPWR VPWR load_addr[10] sky130_fd_sc_hd__buf_2
X_2552_ lsu.current_load_addr\[15\] _1951_ net476 VGND VGND VPWR VPWR _0742_ sky130_fd_sc_hd__mux2_4
XFILLER_99_113 VGND VGND VPWR VPWR sky130_fd_sc_hd__decap_8
Xoutput138 net138 VGND VGND VPWR VPWR store_addr[1] sky130_fd_sc_hd__buf_2
Xoutput127 net127 VGND VGND VPWR VPWR store_addr[0] sky130_fd_sc_hd__buf_2
Xoutput149 net149 VGND VGND VPWR VPWR store_data[0] sky130_fd_sc_hd__buf_2
XFILLER_99_146 VGND VGND VPWR VPWR sky130_fd_sc_hd__decap_6
X_2483_ net96 _1719_ _1898_ _1901_ VGND VGND VPWR VPWR _1902_ sky130_fd_sc_hd__a22o_1
X_4222_ clknet_leaf_52_clk _0279_ VGND VGND VPWR VPWR lsu.store_fifo.queue\[4\]\[0\]
+ sky130_fd_sc_hd__dfxtp_1
XFILLER_68_500 VPWR VGND VPWR VGND sky130_ef_sc_hd__decap_12
XFILLER_68_533 VPWR VGND VPWR VGND sky130_ef_sc_hd__decap_12
X_4153_ clknet_leaf_2_clk _0210_ VGND VGND VPWR VPWR lsu.load_fifo.queue\[11\]\[13\]
+ sky130_fd_sc_hd__dfxtp_1
X_3104_ net292 net790 net186 VGND VGND VPWR VPWR _0608_ sky130_fd_sc_hd__mux2_1
X_4084_ net1247 net246 _1517_ VGND VGND VPWR VPWR _0995_ sky130_fd_sc_hd__o21a_1
XFILLER_83_547 VGND VGND VPWR VPWR sky130_fd_sc_hd__decap_6
X_3035_ net582 net298 net212 VGND VGND VPWR VPWR _0541_ sky130_fd_sc_hd__mux2_1
XFILLER_36_441 VGND VGND VPWR VPWR sky130_fd_sc_hd__fill_1
XFILLER_23_102 VGND VGND VPWR VPWR sky130_fd_sc_hd__fill_1
XFILLER_24_625 VGND VGND VPWR VPWR sky130_fd_sc_hd__decap_4
X_4986_ clknet_leaf_31_clk _1041_ VGND VGND VPWR VPWR lsu.load_fifo.queue\[14\]\[7\]
+ sky130_fd_sc_hd__dfxtp_1
XFILLER_51_444 VGND VGND VPWR VPWR sky130_fd_sc_hd__decap_4
X_3937_ _1386_ _1385_ net360 VGND VGND VPWR VPWR _1387_ sky130_fd_sc_hd__mux2_1
XFILLER_11_308 VGND VGND VPWR VPWR sky130_fd_sc_hd__decap_4
XFILLER_51_477 VGND VGND VPWR VPWR sky130_fd_sc_hd__decap_6
X_3868_ lsu.load_fifo.queue\[12\]\[19\] lsu.load_fifo.queue\[13\]\[19\] lsu.load_fifo.queue\[14\]\[19\]
+ lsu.load_fifo.queue\[15\]\[19\] net386 net368 VGND VGND VPWR VPWR _1328_ sky130_fd_sc_hd__mux4_1
X_3799_ lsu.load_fifo.queue\[8\]\[29\] lsu.load_fifo.queue\[9\]\[29\] lsu.load_fifo.queue\[10\]\[29\]
+ lsu.load_fifo.queue\[11\]\[29\] net394 net377 VGND VGND VPWR VPWR _1269_ sky130_fd_sc_hd__mux4_1
X_2819_ net329 net1143 net226 VGND VGND VPWR VPWR _0332_ sky130_fd_sc_hd__mux2_1
XFILLER_11_57 VGND VGND VPWR VPWR sky130_fd_sc_hd__decap_6
XFILLER_3_529 VPWR VGND VPWR VGND sky130_ef_sc_hd__decap_12
XPHY_EDGE_ROW_52_Left_159 VGND VGND VPWR VPWR sky130_fd_sc_hd__decap_3
XFILLER_87_39 VPWR VGND VPWR VGND sky130_ef_sc_hd__decap_12
XTAP_TAPCELL_ROW_6_301 VGND VPWR sky130_fd_sc_hd__tapvpwrvgnd_1
Xfanout332 lsu.load_fifo.data_in\[11\] VGND VGND VPWR VPWR net332 sky130_fd_sc_hd__clkbuf_2
Xfanout321 lsu.load_fifo.data_in\[17\] VGND VGND VPWR VPWR net321 sky130_fd_sc_hd__buf_1
Xfanout310 lsu.load_fifo.data_in\[22\] VGND VGND VPWR VPWR net310 sky130_fd_sc_hd__clkbuf_2
Xfanout354 net355 VGND VGND VPWR VPWR net354 sky130_fd_sc_hd__clkbuf_2
Xfanout343 lsu.load_fifo.data_in\[6\] VGND VGND VPWR VPWR net343 sky130_fd_sc_hd__dlymetal6s2s_1
Xfanout365 lsu.load_fifo.r_ptr\[2\] VGND VGND VPWR VPWR net365 sky130_fd_sc_hd__buf_2
Xfanout398 net399 VGND VGND VPWR VPWR net398 sky130_fd_sc_hd__buf_2
Xfanout376 net382 VGND VGND VPWR VPWR net376 sky130_fd_sc_hd__clkbuf_4
Xfanout387 net390 VGND VGND VPWR VPWR net387 sky130_fd_sc_hd__buf_4
XFILLER_74_525 VGND VGND VPWR VPWR sky130_fd_sc_hd__fill_1
XPHY_EDGE_ROW_61_Left_168 VGND VGND VPWR VPWR sky130_fd_sc_hd__decap_3
XFILLER_42_477 VGND VGND VPWR VPWR sky130_fd_sc_hd__decap_4
Xinput18 count[4] VGND VGND VPWR VPWR net18 sky130_fd_sc_hd__clkbuf_2
XTAP_TAPCELL_ROW_12_358 VGND VPWR sky130_fd_sc_hd__tapvpwrvgnd_1
XTAP_TAPCELL_ROW_40_667 VGND VPWR sky130_fd_sc_hd__tapvpwrvgnd_1
Xinput29 load_base_addr[14] VGND VGND VPWR VPWR net29 sky130_fd_sc_hd__clkbuf_1
XFILLER_10_363 VGND VGND VPWR VPWR sky130_fd_sc_hd__fill_1
XPHY_EDGE_ROW_70_Left_177 VGND VGND VPWR VPWR sky130_fd_sc_hd__decap_3
XTAP_TAPCELL_ROW_75_1054 VGND VPWR sky130_fd_sc_hd__tapvpwrvgnd_1
XTAP_TAPCELL_ROW_48_756 VGND VPWR sky130_fd_sc_hd__tapvpwrvgnd_1
XFILLER_93_93 VPWR VGND VPWR VGND sky130_ef_sc_hd__decap_12
XTAP_TAPCELL_ROW_86_1172 VGND VPWR sky130_fd_sc_hd__tapvpwrvgnd_1
XFILLER_18_485 VPWR VGND VPWR VGND sky130_ef_sc_hd__decap_12
X_4840_ clknet_leaf_45_clk _0897_ _0090_ VGND VGND VPWR VPWR lsu.store_counter\[17\]
+ sky130_fd_sc_hd__dfrtp_1
XFILLER_33_422 VGND VGND VPWR VPWR sky130_fd_sc_hd__fill_1
XFILLER_21_617 VGND VGND VPWR VPWR sky130_fd_sc_hd__decap_8
XFILLER_60_274 VGND VGND VPWR VPWR sky130_fd_sc_hd__decap_8
X_4771_ clknet_leaf_47_clk net700 VGND VGND VPWR VPWR net135 sky130_fd_sc_hd__dfxtp_1
X_3722_ _1197_ _1202_ VGND VGND VPWR VPWR _1204_ sky130_fd_sc_hd__nand2_1
X_3653_ _1133_ _1134_ VGND VGND VPWR VPWR _1135_ sky130_fd_sc_hd__nand2_1
X_2604_ net35 _1989_ net264 VGND VGND VPWR VPWR _1990_ sky130_fd_sc_hd__mux2_1
X_3584_ net424 VGND VGND VPWR VPWR _0148_ sky130_fd_sc_hd__inv_2
X_2535_ net262 _1931_ VGND VGND VPWR VPWR _1939_ sky130_fd_sc_hd__nor2_1
X_2466_ _1887_ _1889_ net101 net265 VGND VGND VPWR VPWR _1890_ sky130_fd_sc_hd__a2bb2o_1
X_4205_ clknet_leaf_70_clk _0262_ VGND VGND VPWR VPWR lsu.store_fifo.queue\[6\]\[3\]
+ sky130_fd_sc_hd__dfxtp_1
X_2397_ _1720_ _1831_ _1835_ _1722_ VGND VGND VPWR VPWR _1836_ sky130_fd_sc_hd__a31oi_1
XFILLER_68_374 VPWR VGND VPWR VGND sky130_ef_sc_hd__decap_12
X_4136_ clknet_leaf_50_clk _0193_ VGND VGND VPWR VPWR lsu.store_fifo.queue\[10\]\[6\]
+ sky130_fd_sc_hd__dfxtp_1
XFILLER_95_193 VPWR VGND VPWR VGND sky130_ef_sc_hd__decap_12
XFILLER_28_249 VGND VGND VPWR VPWR sky130_fd_sc_hd__decap_3
X_4067_ lsu.store_fifo.queue\[4\]\[4\] lsu.store_fifo.queue\[5\]\[4\] lsu.store_fifo.queue\[6\]\[4\]
+ lsu.store_fifo.queue\[7\]\[4\] net415 net409 VGND VGND VPWR VPWR _1502_ sky130_fd_sc_hd__mux4_1
XFILLER_56_569 VGND VGND VPWR VPWR sky130_fd_sc_hd__decap_8
XFILLER_71_517 VPWR VGND VPWR VGND sky130_ef_sc_hd__decap_12
X_3018_ net701 net332 net210 VGND VGND VPWR VPWR _0524_ sky130_fd_sc_hd__mux2_1
XFILLER_24_455 VGND VGND VPWR VPWR sky130_fd_sc_hd__decap_6
XFILLER_51_241 VGND VGND VPWR VPWR sky130_fd_sc_hd__decap_6
X_4969_ clknet_leaf_75_clk _1024_ _0155_ VGND VGND VPWR VPWR acc.byte2\[6\] sky130_fd_sc_hd__dfrtp_1
XFILLER_98_27 VGND VGND VPWR VPWR sky130_fd_sc_hd__fill_1
XFILLER_78_105 VGND VGND VPWR VPWR sky130_fd_sc_hd__fill_1
Xfanout162 _1666_ VGND VGND VPWR VPWR net162 sky130_fd_sc_hd__buf_8
Xfanout173 _2055_ VGND VGND VPWR VPWR net173 sky130_fd_sc_hd__buf_4
Xfanout184 _2045_ VGND VGND VPWR VPWR net184 sky130_fd_sc_hd__buf_2
Xfanout195 _2000_ VGND VGND VPWR VPWR net195 sky130_fd_sc_hd__buf_4
XTAP_TAPCELL_ROW_17_417 VGND VPWR sky130_fd_sc_hd__tapvpwrvgnd_1
XTAP_TAPCELL_ROW_45_726 VGND VPWR sky130_fd_sc_hd__tapvpwrvgnd_1
XFILLER_70_561 VGND VGND VPWR VPWR sky130_fd_sc_hd__fill_1
XFILLER_70_594 VGND VGND VPWR VPWR sky130_fd_sc_hd__fill_1
XFILLER_30_469 VGND VGND VPWR VPWR sky130_fd_sc_hd__decap_6
XFILLER_6_153 VGND VGND VPWR VPWR sky130_fd_sc_hd__fill_2
XFILLER_6_164 VGND VGND VPWR VPWR sky130_fd_sc_hd__fill_2
XFILLER_6_197 VGND VGND VPWR VPWR sky130_fd_sc_hd__decap_3
XFILLER_88_71 VGND VGND VPWR VPWR sky130_fd_sc_hd__fill_1
X_2320_ lsu.store_counter\[2\] net239 _1725_ lsu.store_counter\[3\] VGND VGND VPWR
+ VPWR _1766_ sky130_fd_sc_hd__a31o_1
XFILLER_97_436 VGND VGND VPWR VPWR sky130_fd_sc_hd__decap_4
X_2251_ lsu.storer_state\[2\] lsu.storer_state\[1\] lsu.storer_state\[0\] VGND VGND
+ VPWR VPWR _1716_ sky130_fd_sc_hd__or3_2
X_2182_ lsu.load_counter\[11\] lsu.load_counter\[10\] _1671_ VGND VGND VPWR VPWR _1672_
+ sky130_fd_sc_hd__and3_1
XTAP_TAPCELL_ROW_88_1201 VGND VPWR sky130_fd_sc_hd__tapvpwrvgnd_1
XFILLER_19_3 VGND VGND VPWR VPWR sky130_fd_sc_hd__decap_3
XFILLER_92_141 VGND VGND VPWR VPWR sky130_fd_sc_hd__decap_6
XFILLER_65_333 VGND VGND VPWR VPWR sky130_fd_sc_hd__decap_3
XFILLER_92_152 VPWR VGND VPWR VGND sky130_ef_sc_hd__decap_12
XFILLER_61_561 VGND VGND VPWR VPWR sky130_fd_sc_hd__fill_1
X_4823_ clknet_leaf_36_clk _0880_ _0073_ VGND VGND VPWR VPWR lsu.store_counter\[0\]
+ sky130_fd_sc_hd__dfrtp_1
XFILLER_33_296 VGND VGND VPWR VPWR sky130_fd_sc_hd__fill_1
X_4754_ clknet_leaf_47_clk _0811_ VGND VGND VPWR VPWR net127 sky130_fd_sc_hd__dfxtp_1
XFILLER_21_447 VGND VGND VPWR VPWR sky130_fd_sc_hd__fill_1
X_3705_ _1181_ _1186_ VGND VGND VPWR VPWR _1187_ sky130_fd_sc_hd__nor2_1
X_4685_ clknet_leaf_28_clk _0742_ _0031_ VGND VGND VPWR VPWR lsu.current_load_addr\[15\]
+ sky130_fd_sc_hd__dfrtp_1
X_3636_ net7 VGND VGND VPWR VPWR _1118_ sky130_fd_sc_hd__inv_2
X_3567_ net433 VGND VGND VPWR VPWR _0131_ sky130_fd_sc_hd__inv_2
X_2518_ lsu.current_load_addr\[7\] _1923_ VGND VGND VPWR VPWR _1924_ sky130_fd_sc_hd__nand2_1
XFILLER_88_458 VPWR VGND VPWR VGND sky130_ef_sc_hd__decap_12
X_3498_ net441 VGND VGND VPWR VPWR _0062_ sky130_fd_sc_hd__inv_2
X_2449_ net1296 net252 _1876_ _1877_ VGND VGND VPWR VPWR _0803_ sky130_fd_sc_hd__a22o_1
X_4119_ net46 _1547_ VGND VGND VPWR VPWR _1549_ sky130_fd_sc_hd__nand2_1
XFILLER_56_333 VGND VGND VPWR VPWR sky130_fd_sc_hd__fill_1
XTAP_TAPCELL_ROW_104_1378 VGND VPWR sky130_fd_sc_hd__tapvpwrvgnd_1
XFILLER_33_11 VGND VGND VPWR VPWR sky130_fd_sc_hd__fill_2
XFILLER_52_583 VGND VGND VPWR VPWR sky130_fd_sc_hd__decap_4
XFILLER_12_469 VGND VGND VPWR VPWR sky130_fd_sc_hd__decap_6
XTAP_TAPCELL_ROW_22_475 VGND VPWR sky130_fd_sc_hd__tapvpwrvgnd_1
XTAP_TAPCELL_ROW_50_784 VGND VPWR sky130_fd_sc_hd__tapvpwrvgnd_1
XFILLER_4_613 VPWR VGND VPWR VGND sky130_ef_sc_hd__decap_12
XTAP_TAPCELL_ROW_72_1024 VGND VPWR sky130_fd_sc_hd__tapvpwrvgnd_1
XFILLER_3_178 VGND VGND VPWR VPWR sky130_fd_sc_hd__decap_4
XFILLER_79_447 VGND VGND VPWR VPWR sky130_fd_sc_hd__fill_1
XFILLER_58_85 VGND VGND VPWR VPWR sky130_fd_sc_hd__fill_2
XFILLER_58_96 VGND VGND VPWR VPWR sky130_fd_sc_hd__decap_3
XFILLER_59_182 VGND VGND VPWR VPWR sky130_fd_sc_hd__decap_4
XFILLER_101_290 VGND VGND VPWR VPWR sky130_fd_sc_hd__decap_3
XFILLER_47_344 VGND VGND VPWR VPWR sky130_fd_sc_hd__fill_1
XTAP_TAPCELL_ROW_58_873 VGND VPWR sky130_fd_sc_hd__tapvpwrvgnd_1
XTAP_TAPCELL_ROW_83_1142 VGND VPWR sky130_fd_sc_hd__tapvpwrvgnd_1
XFILLER_43_561 VGND VGND VPWR VPWR sky130_fd_sc_hd__decap_4
XFILLER_90_83 VGND VGND VPWR VPWR sky130_fd_sc_hd__fill_1
XFILLER_30_299 VGND VGND VPWR VPWR sky130_fd_sc_hd__fill_1
Xhold418 lsu.load_fifo.queue\[0\]\[25\] VGND VGND VPWR VPWR net886 sky130_fd_sc_hd__dlygate4sd3_1
XFILLER_7_473 VPWR VGND VPWR VGND sky130_ef_sc_hd__decap_12
Xhold407 lsu.store_fifo.queue\[8\]\[9\] VGND VGND VPWR VPWR net875 sky130_fd_sc_hd__dlygate4sd3_1
X_4470_ clknet_leaf_3_clk _0527_ VGND VGND VPWR VPWR lsu.load_fifo.queue\[3\]\[14\]
+ sky130_fd_sc_hd__dfxtp_1
XFILLER_99_81 VPWR VGND VPWR VGND sky130_ef_sc_hd__decap_12
X_3421_ net283 net1061 _2058_ VGND VGND VPWR VPWR _1070_ sky130_fd_sc_hd__mux2_1
Xhold429 net133 VGND VGND VPWR VPWR net897 sky130_fd_sc_hd__dlygate4sd3_1
XTAP_TAPCELL_ROW_94_1260 VGND VPWR sky130_fd_sc_hd__tapvpwrvgnd_1
X_3352_ net352 net1077 net169 VGND VGND VPWR VPWR _0961_ sky130_fd_sc_hd__mux2_1
X_2303_ lsu.store_counter\[10\] _1721_ VGND VGND VPWR VPWR _1756_ sky130_fd_sc_hd__nor2_1
XFILLER_97_277 VGND VGND VPWR VPWR sky130_fd_sc_hd__decap_3
X_3283_ net1135 net272 _2053_ VGND VGND VPWR VPWR _0846_ sky130_fd_sc_hd__mux2_1
XFILLER_57_108 VGND VGND VPWR VPWR sky130_fd_sc_hd__decap_4
X_2234_ _1105_ lsu.load_counter\[3\] _1667_ VGND VGND VPWR VPWR _1706_ sky130_fd_sc_hd__and3_1
X_5022_ clknet_leaf_72_clk _1077_ _0166_ VGND VGND VPWR VPWR acc.data_out\[1\] sky130_fd_sc_hd__dfrtp_1
X_2165_ _1568_ lsu.load_counter\[20\] _1583_ lsu.load_counter\[19\] VGND VGND VPWR
+ VPWR _1655_ sky130_fd_sc_hd__a22o_1
XFILLER_93_461 VGND VGND VPWR VPWR sky130_fd_sc_hd__fill_2
XFILLER_65_152 VGND VGND VPWR VPWR sky130_fd_sc_hd__fill_1
X_2096_ net8 net469 VGND VGND VPWR VPWR _1586_ sky130_fd_sc_hd__xor2_4
XFILLER_0_81 VGND VGND VPWR VPWR sky130_fd_sc_hd__decap_3
X_4806_ clknet_leaf_27_clk _0863_ VGND VGND VPWR VPWR lsu.load_fifo.data_in\[16\]
+ sky130_fd_sc_hd__dfxtp_1
XFILLER_21_222 VGND VGND VPWR VPWR sky130_fd_sc_hd__fill_2
XFILLER_21_233 VGND VGND VPWR VPWR sky130_fd_sc_hd__fill_1
XFILLER_9_90 VGND VGND VPWR VPWR sky130_fd_sc_hd__decap_4
X_2998_ net1091 net305 net190 VGND VGND VPWR VPWR _0506_ sky130_fd_sc_hd__mux2_1
X_4737_ clknet_leaf_48_clk _0794_ _0051_ VGND VGND VPWR VPWR lsu.current_store_addr\[5\]
+ sky130_fd_sc_hd__dfrtp_1
X_4668_ clknet_leaf_49_clk _0725_ VGND VGND VPWR VPWR lsu.store_fifo.queue\[15\]\[8\]
+ sky130_fd_sc_hd__dfxtp_1
X_3619_ lsu.load_counter\[10\] VGND VGND VPWR VPWR _1102_ sky130_fd_sc_hd__inv_2
X_4599_ clknet_leaf_10_clk _0656_ VGND VGND VPWR VPWR lsu.load_fifo.queue\[8\]\[15\]
+ sky130_fd_sc_hd__dfxtp_1
XFILLER_95_39 VPWR VGND VPWR VGND sky130_ef_sc_hd__decap_12
XFILLER_0_137 VGND VGND VPWR VPWR sky130_fd_sc_hd__decap_3
XFILLER_103_599 VPWR VGND VPWR VGND sky130_ef_sc_hd__decap_12
XFILLER_88_277 VPWR VGND VPWR VGND sky130_ef_sc_hd__decap_12
XFILLER_57_620 VGND VGND VPWR VPWR sky130_fd_sc_hd__fill_2
XFILLER_28_33 VGND VGND VPWR VPWR sky130_fd_sc_hd__fill_1
XTAP_TAPCELL_ROW_106_1407 VGND VPWR sky130_fd_sc_hd__tapvpwrvgnd_1
XFILLER_17_517 VPWR VGND VPWR VGND sky130_ef_sc_hd__decap_12
XFILLER_71_133 VGND VGND VPWR VPWR sky130_fd_sc_hd__fill_1
XTAP_TAPCELL_ROW_27_523 VGND VPWR sky130_fd_sc_hd__tapvpwrvgnd_1
XTAP_TAPCELL_ROW_55_832 VGND VPWR sky130_fd_sc_hd__tapvpwrvgnd_1
XFILLER_71_177 VGND VGND VPWR VPWR sky130_fd_sc_hd__decap_3
XFILLER_5_15 VPWR VGND VPWR VGND sky130_ef_sc_hd__decap_12
XFILLER_4_421 VPWR VGND VPWR VGND sky130_ef_sc_hd__decap_12
XFILLER_79_277 VGND VGND VPWR VPWR sky130_fd_sc_hd__decap_3
XFILLER_48_620 VGND VGND VPWR VPWR sky130_fd_sc_hd__fill_2
XPHY_EDGE_ROW_13_Right_13 VGND VGND VPWR VPWR sky130_fd_sc_hd__decap_3
XFILLER_75_461 VPWR VGND VPWR VGND sky130_ef_sc_hd__decap_12
XFILLER_90_475 VGND VGND VPWR VPWR sky130_fd_sc_hd__fill_1
X_3970_ _1414_ _1413_ net364 VGND VGND VPWR VPWR _1415_ sky130_fd_sc_hd__mux2_1
XFILLER_62_144 VGND VGND VPWR VPWR sky130_fd_sc_hd__decap_4
X_2921_ net945 net322 net221 VGND VGND VPWR VPWR _0433_ sky130_fd_sc_hd__mux2_1
XFILLER_31_531 VGND VGND VPWR VPWR sky130_fd_sc_hd__decap_3
XFILLER_86_3 VPWR VGND VPWR VGND sky130_ef_sc_hd__decap_12
X_2852_ net542 net330 net224 VGND VGND VPWR VPWR _0363_ sky130_fd_sc_hd__mux2_1
XPHY_EDGE_ROW_22_Right_22 VGND VGND VPWR VPWR sky130_fd_sc_hd__decap_3
X_2783_ _2020_ _2029_ VGND VGND VPWR VPWR _2031_ sky130_fd_sc_hd__nor2_4
X_4522_ clknet_leaf_22_clk _0579_ VGND VGND VPWR VPWR lsu.load_fifo.queue\[1\]\[2\]
+ sky130_fd_sc_hd__dfxtp_1
Xhold215 lsu.load_fifo.queue\[3\]\[24\] VGND VGND VPWR VPWR net683 sky130_fd_sc_hd__dlygate4sd3_1
X_4453_ clknet_leaf_22_clk _0510_ VGND VGND VPWR VPWR lsu.load_fifo.queue\[4\]\[29\]
+ sky130_fd_sc_hd__dfxtp_1
XFILLER_7_281 VGND VGND VPWR VPWR sky130_fd_sc_hd__decap_3
Xhold204 lsu.load_fifo.queue\[15\]\[13\] VGND VGND VPWR VPWR net672 sky130_fd_sc_hd__dlygate4sd3_1
Xhold226 lsu.load_fifo.queue\[12\]\[5\] VGND VGND VPWR VPWR net694 sky130_fd_sc_hd__dlygate4sd3_1
X_3404_ net1165 net314 net198 VGND VGND VPWR VPWR _1054_ sky130_fd_sc_hd__mux2_1
Xhold237 lsu.load_fifo.queue\[15\]\[14\] VGND VGND VPWR VPWR net705 sky130_fd_sc_hd__dlygate4sd3_1
Xhold259 lsu.load_fifo.queue\[15\]\[19\] VGND VGND VPWR VPWR net727 sky130_fd_sc_hd__dlygate4sd3_1
Xhold248 lsu.load_fifo.queue\[12\]\[30\] VGND VGND VPWR VPWR net716 sky130_fd_sc_hd__dlygate4sd3_1
X_4384_ clknet_leaf_32_clk _0441_ VGND VGND VPWR VPWR lsu.load_fifo.queue\[6\]\[24\]
+ sky130_fd_sc_hd__dfxtp_1
X_3335_ net962 net321 net174 VGND VGND VPWR VPWR _0945_ sky130_fd_sc_hd__mux2_1
XFILLER_100_514 VGND VGND VPWR VPWR sky130_fd_sc_hd__fill_1
XFILLER_98_597 VGND VGND VPWR VPWR sky130_fd_sc_hd__fill_1
XPHY_EDGE_ROW_31_Right_31 VGND VGND VPWR VPWR sky130_fd_sc_hd__decap_3
X_3266_ lsu.current_store_addr\[15\] net897 _2052_ VGND VGND VPWR VPWR _0826_ sky130_fd_sc_hd__mux2_1
X_2217_ lsu.load_counter\[11\] _1695_ _1693_ VGND VGND VPWR VPWR _0916_ sky130_fd_sc_hd__o21ba_1
X_5005_ clknet_leaf_17_clk _1060_ VGND VGND VPWR VPWR lsu.load_fifo.queue\[14\]\[26\]
+ sky130_fd_sc_hd__dfxtp_1
XFILLER_66_472 VGND VGND VPWR VPWR sky130_fd_sc_hd__decap_4
X_3197_ net1072 net304 net203 VGND VGND VPWR VPWR _0698_ sky130_fd_sc_hd__mux2_1
X_2148_ net2 net13 VGND VGND VPWR VPWR _1638_ sky130_fd_sc_hd__and2_1
XFILLER_53_111 VGND VGND VPWR VPWR sky130_fd_sc_hd__fill_1
X_2079_ net15 _1567_ VGND VGND VPWR VPWR _1569_ sky130_fd_sc_hd__nor2_1
XFILLER_53_166 VGND VGND VPWR VPWR sky130_fd_sc_hd__fill_2
XTAP_TAPCELL_ROW_52_802 VGND VPWR sky130_fd_sc_hd__tapvpwrvgnd_1
XFILLER_41_317 VGND VGND VPWR VPWR sky130_fd_sc_hd__fill_1
XTAP_TAPCELL_ROW_101_1337 VGND VPWR sky130_fd_sc_hd__tapvpwrvgnd_1
XPHY_EDGE_ROW_40_Right_40 VGND VGND VPWR VPWR sky130_fd_sc_hd__decap_3
XTAP_TAPCELL_ROW_32_581 VGND VPWR sky130_fd_sc_hd__tapvpwrvgnd_1
XTAP_TAPCELL_ROW_60_890 VGND VPWR sky130_fd_sc_hd__tapvpwrvgnd_1
Xhold771 net159 VGND VGND VPWR VPWR net1239 sky130_fd_sc_hd__dlygate4sd3_1
Xhold760 lsu.load_fifo.queue\[1\]\[16\] VGND VGND VPWR VPWR net1228 sky130_fd_sc_hd__dlygate4sd3_1
Xhold782 lsu.load_fifo.data_in\[26\] VGND VGND VPWR VPWR net1250 sky130_fd_sc_hd__dlygate4sd3_1
XFILLER_39_21 VGND VGND VPWR VPWR sky130_fd_sc_hd__decap_3
Xhold793 acc.byte0\[5\] VGND VGND VPWR VPWR net1261 sky130_fd_sc_hd__dlygate4sd3_1
XFILLER_91_217 VGND VGND VPWR VPWR sky130_fd_sc_hd__decap_6
XTAP_TAPCELL_ROW_4_273 VGND VPWR sky130_fd_sc_hd__tapvpwrvgnd_1
XFILLER_44_111 VGND VGND VPWR VPWR sky130_fd_sc_hd__decap_3
XFILLER_55_53 VGND VGND VPWR VPWR sky130_fd_sc_hd__decap_3
XFILLER_72_475 VGND VGND VPWR VPWR sky130_fd_sc_hd__fill_1
XFILLER_32_306 VGND VGND VPWR VPWR sky130_fd_sc_hd__fill_2
XTAP_TAPCELL_ROW_80_1112 VGND VPWR sky130_fd_sc_hd__tapvpwrvgnd_1
XFILLER_13_553 VGND VGND VPWR VPWR sky130_fd_sc_hd__decap_6
XFILLER_25_391 VGND VGND VPWR VPWR sky130_fd_sc_hd__fill_1
XFILLER_71_52 VGND VGND VPWR VPWR sky130_fd_sc_hd__decap_4
XFILLER_13_597 VPWR VGND VPWR VGND sky130_ef_sc_hd__decap_12
XTAP_TAPCELL_ROW_78_1085 VGND VPWR sky130_fd_sc_hd__tapvpwrvgnd_1
XFILLER_4_251 VGND VGND VPWR VPWR sky130_fd_sc_hd__fill_1
XTAP_TAPCELL_ROW_91_1230 VGND VPWR sky130_fd_sc_hd__tapvpwrvgnd_1
X_3120_ net804 net327 net181 VGND VGND VPWR VPWR _0623_ sky130_fd_sc_hd__mux2_1
X_3051_ net846 net332 net206 VGND VGND VPWR VPWR _0556_ sky130_fd_sc_hd__mux2_1
XFILLER_35_111 VGND VGND VPWR VPWR sky130_fd_sc_hd__fill_1
XFILLER_35_122 VGND VGND VPWR VPWR sky130_fd_sc_hd__fill_1
XFILLER_50_147 VGND VGND VPWR VPWR sky130_fd_sc_hd__fill_1
X_3953_ net1295 _1400_ net256 VGND VGND VPWR VPWR _1009_ sky130_fd_sc_hd__mux2_1
X_2904_ net416 net418 _2034_ VGND VGND VPWR VPWR _2036_ sky130_fd_sc_hd__and3b_4
X_3884_ lsu.load_fifo.queue\[4\]\[16\] lsu.load_fifo.queue\[5\]\[16\] lsu.load_fifo.queue\[6\]\[16\]
+ lsu.load_fifo.queue\[7\]\[16\] net396 net379 VGND VGND VPWR VPWR _1341_ sky130_fd_sc_hd__mux4_1
X_2835_ net297 net1168 net228 VGND VGND VPWR VPWR _0348_ sky130_fd_sc_hd__mux2_1
XFILLER_31_383 VGND VGND VPWR VPWR sky130_fd_sc_hd__fill_1
X_2766_ net929 net281 _2028_ VGND VGND VPWR VPWR _0284_ sky130_fd_sc_hd__mux2_1
XFILLER_105_617 VGND VGND VPWR VPWR sky130_fd_sc_hd__decap_8
X_2697_ net991 net307 net233 VGND VGND VPWR VPWR _0221_ sky130_fd_sc_hd__mux2_1
X_4505_ clknet_leaf_69_clk _0562_ VGND VGND VPWR VPWR lsu.load_fifo.queue\[2\]\[17\]
+ sky130_fd_sc_hd__dfxtp_1
X_4436_ clknet_leaf_19_clk _0493_ VGND VGND VPWR VPWR lsu.load_fifo.queue\[4\]\[12\]
+ sky130_fd_sc_hd__dfxtp_1
X_4367_ clknet_leaf_32_clk _0424_ VGND VGND VPWR VPWR lsu.load_fifo.queue\[6\]\[7\]
+ sky130_fd_sc_hd__dfxtp_1
X_3318_ net640 net354 net176 VGND VGND VPWR VPWR _0928_ sky130_fd_sc_hd__mux2_1
XFILLER_86_545 VGND VGND VPWR VPWR sky130_fd_sc_hd__decap_8
X_4298_ clknet_leaf_18_clk _0355_ VGND VGND VPWR VPWR lsu.load_fifo.queue\[10\]\[4\]
+ sky130_fd_sc_hd__dfxtp_1
X_3249_ net585 lsu.current_load_addr\[21\] net237 VGND VGND VPWR VPWR _0787_ sky130_fd_sc_hd__mux2_1
XFILLER_86_589 VGND VGND VPWR VPWR sky130_fd_sc_hd__decap_3
XFILLER_86_578 VGND VGND VPWR VPWR sky130_fd_sc_hd__decap_8
XTAP_TAPCELL_ROW_1_243 VGND VPWR sky130_fd_sc_hd__tapvpwrvgnd_1
XFILLER_92_29 VPWR VGND VPWR VGND sky130_ef_sc_hd__decap_12
XTAP_TAPCELL_ROW_37_640 VGND VPWR sky130_fd_sc_hd__tapvpwrvgnd_1
XFILLER_81_294 VGND VGND VPWR VPWR sky130_fd_sc_hd__decap_4
XFILLER_10_501 VPWR VGND VPWR VGND sky130_ef_sc_hd__decap_12
XFILLER_22_361 VGND VGND VPWR VPWR sky130_fd_sc_hd__decap_3
XFILLER_25_89 VGND VGND VPWR VPWR sky130_fd_sc_hd__decap_3
XFILLER_41_169 VGND VGND VPWR VPWR sky130_fd_sc_hd__decap_3
XFILLER_10_545 VPWR VGND VPWR VGND sky130_ef_sc_hd__decap_12
XFILLER_10_589 VPWR VGND VPWR VGND sky130_ef_sc_hd__decap_12
XFILLER_41_77 VGND VGND VPWR VPWR sky130_fd_sc_hd__fill_1
XTAP_TAPCELL_ROW_9_332 VGND VPWR sky130_fd_sc_hd__tapvpwrvgnd_1
XFILLER_96_309 VPWR VGND VPWR VGND sky130_ef_sc_hd__decap_12
XFILLER_89_350 VPWR VGND VPWR VGND sky130_ef_sc_hd__decap_12
Xhold590 lsu.load_fifo.queue\[13\]\[2\] VGND VGND VPWR VPWR net1058 sky130_fd_sc_hd__dlygate4sd3_1
XFILLER_77_512 VPWR VGND VPWR VGND sky130_ef_sc_hd__decap_12
XFILLER_1_254 VGND VGND VPWR VPWR sky130_fd_sc_hd__decap_4
XFILLER_2_27 VGND VGND VPWR VPWR sky130_fd_sc_hd__fill_1
XFILLER_18_601 VPWR VGND VPWR VGND sky130_ef_sc_hd__decap_12
XFILLER_66_85 VGND VGND VPWR VPWR sky130_fd_sc_hd__fill_1
XFILLER_17_144 VGND VGND VPWR VPWR sky130_fd_sc_hd__decap_6
XFILLER_45_453 VGND VGND VPWR VPWR sky130_fd_sc_hd__fill_1
XTAP_TAPCELL_ROW_63_919 VGND VPWR sky130_fd_sc_hd__tapvpwrvgnd_1
XFILLER_45_497 VGND VGND VPWR VPWR sky130_fd_sc_hd__decap_6
XFILLER_32_136 VGND VGND VPWR VPWR sky130_fd_sc_hd__decap_4
XTAP_TAPCELL_ROW_43_698 VGND VPWR sky130_fd_sc_hd__tapvpwrvgnd_1
X_2620_ net416 _1999_ VGND VGND VPWR VPWR _2000_ sky130_fd_sc_hd__nor2_4
Xoutput106 net106 VGND VGND VPWR VPWR load_addr[11] sky130_fd_sc_hd__buf_2
X_2551_ net30 net260 _1949_ _1950_ VGND VGND VPWR VPWR _1951_ sky130_fd_sc_hd__a22o_1
Xoutput117 net117 VGND VGND VPWR VPWR load_addr[21] sky130_fd_sc_hd__buf_2
Xoutput139 net139 VGND VGND VPWR VPWR store_addr[20] sky130_fd_sc_hd__buf_2
Xoutput128 net128 VGND VGND VPWR VPWR store_addr[10] sky130_fd_sc_hd__buf_2
X_2482_ lsu.current_store_addr\[4\] _1842_ VGND VGND VPWR VPWR _1901_ sky130_fd_sc_hd__or2_1
X_4221_ clknet_leaf_70_clk _0278_ VGND VGND VPWR VPWR lsu.store_fifo.queue\[5\]\[9\]
+ sky130_fd_sc_hd__dfxtp_1
XFILLER_49_3 VGND VGND VPWR VPWR sky130_fd_sc_hd__decap_3
XFILLER_68_512 VPWR VGND VPWR VGND sky130_ef_sc_hd__decap_12
XFILLER_68_545 VPWR VGND VPWR VGND sky130_ef_sc_hd__decap_12
X_4152_ clknet_leaf_20_clk _0209_ VGND VGND VPWR VPWR lsu.load_fifo.queue\[11\]\[12\]
+ sky130_fd_sc_hd__dfxtp_1
XFILLER_95_353 VGND VGND VPWR VPWR sky130_fd_sc_hd__fill_1
XFILLER_68_589 VGND VGND VPWR VPWR sky130_fd_sc_hd__fill_2
X_4083_ net246 _1516_ VGND VGND VPWR VPWR _1517_ sky130_fd_sc_hd__nand2_1
X_3103_ net295 net1043 net187 VGND VGND VPWR VPWR _0607_ sky130_fd_sc_hd__mux2_1
X_3034_ net737 net300 net211 VGND VGND VPWR VPWR _0540_ sky130_fd_sc_hd__mux2_1
XFILLER_91_581 VGND VGND VPWR VPWR sky130_fd_sc_hd__decap_8
X_4985_ clknet_leaf_0_clk _1040_ VGND VGND VPWR VPWR lsu.load_fifo.queue\[14\]\[6\]
+ sky130_fd_sc_hd__dfxtp_1
X_3936_ lsu.load_fifo.queue\[8\]\[9\] lsu.load_fifo.queue\[9\]\[9\] lsu.load_fifo.queue\[10\]\[9\]
+ lsu.load_fifo.queue\[11\]\[9\] net387 net370 VGND VGND VPWR VPWR _1386_ sky130_fd_sc_hd__mux4_1
X_3867_ lsu.load_fifo.queue\[0\]\[19\] lsu.load_fifo.queue\[1\]\[19\] lsu.load_fifo.queue\[2\]\[19\]
+ lsu.load_fifo.queue\[3\]\[19\] net385 net372 VGND VGND VPWR VPWR _1327_ sky130_fd_sc_hd__mux4_1
X_3798_ lsu.load_fifo.queue\[12\]\[29\] lsu.load_fifo.queue\[13\]\[29\] lsu.load_fifo.queue\[14\]\[29\]
+ lsu.load_fifo.queue\[15\]\[29\] net394 net377 VGND VGND VPWR VPWR _1268_ sky130_fd_sc_hd__mux4_1
X_2818_ net331 net723 net228 VGND VGND VPWR VPWR _0331_ sky130_fd_sc_hd__mux2_1
X_2749_ net420 _2012_ _2014_ VGND VGND VPWR VPWR _2027_ sky130_fd_sc_hd__or3_4
Xfanout322 lsu.load_fifo.data_in\[16\] VGND VGND VPWR VPWR net322 sky130_fd_sc_hd__clkbuf_2
X_4419_ clknet_leaf_81_clk _0476_ VGND VGND VPWR VPWR lsu.load_fifo.queue\[5\]\[27\]
+ sky130_fd_sc_hd__dfxtp_1
Xfanout300 lsu.load_fifo.data_in\[27\] VGND VGND VPWR VPWR net300 sky130_fd_sc_hd__clkbuf_2
Xfanout311 lsu.load_fifo.data_in\[22\] VGND VGND VPWR VPWR net311 sky130_fd_sc_hd__buf_1
Xfanout355 lsu.load_fifo.data_in\[0\] VGND VGND VPWR VPWR net355 sky130_fd_sc_hd__dlymetal6s2s_1
Xfanout333 lsu.load_fifo.data_in\[11\] VGND VGND VPWR VPWR net333 sky130_fd_sc_hd__dlymetal6s2s_1
Xfanout366 net369 VGND VGND VPWR VPWR net366 sky130_fd_sc_hd__clkbuf_4
Xfanout344 lsu.load_fifo.data_in\[5\] VGND VGND VPWR VPWR net344 sky130_fd_sc_hd__clkbuf_2
Xfanout399 lsu.load_fifo.r_ptr\[0\] VGND VGND VPWR VPWR net399 sky130_fd_sc_hd__clkbuf_4
Xfanout377 net382 VGND VGND VPWR VPWR net377 sky130_fd_sc_hd__buf_2
Xfanout388 net390 VGND VGND VPWR VPWR net388 sky130_fd_sc_hd__buf_4
XFILLER_15_615 VGND VGND VPWR VPWR sky130_fd_sc_hd__fill_1
Xinput19 count[5] VGND VGND VPWR VPWR net19 sky130_fd_sc_hd__buf_1
XTAP_TAPCELL_ROW_12_359 VGND VPWR sky130_fd_sc_hd__tapvpwrvgnd_1
XTAP_TAPCELL_ROW_40_668 VGND VPWR sky130_fd_sc_hd__tapvpwrvgnd_1
XTAP_TAPCELL_ROW_75_1055 VGND VPWR sky130_fd_sc_hd__tapvpwrvgnd_1
XFILLER_96_139 VGND VGND VPWR VPWR sky130_fd_sc_hd__fill_1
XFILLER_89_191 VPWR VGND VPWR VGND sky130_ef_sc_hd__decap_12
XFILLER_77_320 VGND VGND VPWR VPWR sky130_fd_sc_hd__decap_8
XFILLER_77_364 VGND VGND VPWR VPWR sky130_fd_sc_hd__fill_1
XFILLER_92_301 VGND VGND VPWR VPWR sky130_fd_sc_hd__decap_6
XFILLER_37_239 VGND VGND VPWR VPWR sky130_fd_sc_hd__fill_2
XTAP_TAPCELL_ROW_48_757 VGND VPWR sky130_fd_sc_hd__tapvpwrvgnd_1
XTAP_TAPCELL_ROW_86_1173 VGND VPWR sky130_fd_sc_hd__tapvpwrvgnd_1
XFILLER_80_518 VPWR VGND VPWR VGND sky130_ef_sc_hd__decap_12
XFILLER_18_475 VGND VGND VPWR VPWR sky130_fd_sc_hd__fill_1
XFILLER_45_261 VGND VGND VPWR VPWR sky130_fd_sc_hd__decap_6
XFILLER_18_497 VPWR VGND VPWR VGND sky130_ef_sc_hd__decap_12
X_4770_ clknet_leaf_47_clk _0827_ VGND VGND VPWR VPWR net134 sky130_fd_sc_hd__dfxtp_1
XFILLER_9_151 VGND VGND VPWR VPWR sky130_fd_sc_hd__fill_1
X_3721_ _1197_ _1202_ VGND VGND VPWR VPWR _1203_ sky130_fd_sc_hd__nor2_1
X_3652_ acc.byte1\[5\] acc.byte0\[5\] VGND VGND VPWR VPWR _1134_ sky130_fd_sc_hd__or2_1
X_2603_ lsu.current_load_addr\[1\] lsu.current_load_addr\[0\] VGND VGND VPWR VPWR
+ _1989_ sky130_fd_sc_hd__xor2_1
X_3583_ net422 VGND VGND VPWR VPWR _0147_ sky130_fd_sc_hd__inv_2
X_2534_ _1934_ _1935_ _1938_ net1275 VGND VGND VPWR VPWR _0747_ sky130_fd_sc_hd__o2bb2a_4
X_2465_ lsu.current_store_addr\[9\] _1847_ VGND VGND VPWR VPWR _1889_ sky130_fd_sc_hd__nor2_1
X_2396_ lsu.store_counter\[22\] _1570_ _1834_ VGND VGND VPWR VPWR _1835_ sky130_fd_sc_hd__o21ai_2
X_4204_ clknet_leaf_56_clk _0261_ VGND VGND VPWR VPWR lsu.store_fifo.queue\[6\]\[2\]
+ sky130_fd_sc_hd__dfxtp_1
XFILLER_3_81 VPWR VGND VPWR VGND sky130_ef_sc_hd__decap_12
X_4135_ clknet_leaf_65_clk _0192_ VGND VGND VPWR VPWR lsu.store_fifo.queue\[10\]\[5\]
+ sky130_fd_sc_hd__dfxtp_1
XFILLER_68_386 VGND VGND VPWR VPWR sky130_fd_sc_hd__decap_3
XFILLER_83_345 VGND VGND VPWR VPWR sky130_fd_sc_hd__fill_1
XFILLER_83_334 VGND VGND VPWR VPWR sky130_fd_sc_hd__fill_2
X_4066_ net271 _1500_ VGND VGND VPWR VPWR _1501_ sky130_fd_sc_hd__nor2_1
X_3017_ net785 net335 net212 VGND VGND VPWR VPWR _0523_ sky130_fd_sc_hd__mux2_1
XFILLER_71_529 VGND VGND VPWR VPWR sky130_fd_sc_hd__decap_8
XFILLER_36_250 VGND VGND VPWR VPWR sky130_fd_sc_hd__fill_2
XFILLER_51_264 VGND VGND VPWR VPWR sky130_fd_sc_hd__fill_2
XFILLER_12_629 VGND VGND VPWR VPWR sky130_fd_sc_hd__fill_1
XFILLER_51_275 VGND VGND VPWR VPWR sky130_fd_sc_hd__decap_4
X_4968_ clknet_leaf_14_clk _1023_ _0154_ VGND VGND VPWR VPWR acc.byte2\[5\] sky130_fd_sc_hd__dfrtp_1
X_3919_ lsu.load_fifo.queue\[12\]\[11\] lsu.load_fifo.queue\[13\]\[11\] lsu.load_fifo.queue\[14\]\[11\]
+ lsu.load_fifo.queue\[15\]\[11\] net383 net366 VGND VGND VPWR VPWR _1371_ sky130_fd_sc_hd__mux4_1
X_4899_ clknet_leaf_17_clk _0954_ VGND VGND VPWR VPWR lsu.load_fifo.queue\[12\]\[26\]
+ sky130_fd_sc_hd__dfxtp_1
XFILLER_22_57 VGND VGND VPWR VPWR sky130_fd_sc_hd__fill_1
Xfanout163 net165 VGND VGND VPWR VPWR net163 sky130_fd_sc_hd__buf_8
Xfanout174 _2055_ VGND VGND VPWR VPWR net174 sky130_fd_sc_hd__clkbuf_4
XFILLER_101_472 VGND VGND VPWR VPWR sky130_fd_sc_hd__fill_1
XFILLER_101_461 VGND VGND VPWR VPWR sky130_fd_sc_hd__decap_3
Xfanout196 _2000_ VGND VGND VPWR VPWR net196 sky130_fd_sc_hd__buf_2
Xfanout185 _2044_ VGND VGND VPWR VPWR net185 sky130_fd_sc_hd__buf_4
XFILLER_47_54 VGND VGND VPWR VPWR sky130_fd_sc_hd__fill_2
XFILLER_15_401 VPWR VGND VPWR VGND sky130_ef_sc_hd__decap_12
XTAP_TAPCELL_ROW_17_418 VGND VPWR sky130_fd_sc_hd__tapvpwrvgnd_1
XTAP_TAPCELL_ROW_45_727 VGND VPWR sky130_fd_sc_hd__tapvpwrvgnd_1
XFILLER_15_445 VGND VGND VPWR VPWR sky130_fd_sc_hd__decap_3
XPHY_EDGE_ROW_69_Right_69 VGND VGND VPWR VPWR sky130_fd_sc_hd__decap_3
XPHY_EDGE_ROW_78_Right_78 VGND VGND VPWR VPWR sky130_fd_sc_hd__decap_3
X_2250_ lsu.storer_state\[2\] lsu.storer_state\[0\] VGND VGND VPWR VPWR _1715_ sky130_fd_sc_hd__nor2_1
XFILLER_2_382 VPWR VGND VPWR VGND sky130_ef_sc_hd__decap_12
X_2181_ lsu.load_counter\[9\] lsu.load_counter\[8\] _1670_ VGND VGND VPWR VPWR _1671_
+ sky130_fd_sc_hd__and3_1
XTAP_TAPCELL_ROW_88_1202 VGND VPWR sky130_fd_sc_hd__tapvpwrvgnd_1
XFILLER_38_548 VGND VGND VPWR VPWR sky130_fd_sc_hd__fill_1
XFILLER_65_345 VGND VGND VPWR VPWR sky130_fd_sc_hd__decap_8
XFILLER_92_164 VPWR VGND VPWR VGND sky130_ef_sc_hd__decap_12
XFILLER_92_197 VPWR VGND VPWR VGND sky130_ef_sc_hd__decap_12
XPHY_EDGE_ROW_87_Right_87 VGND VGND VPWR VPWR sky130_fd_sc_hd__decap_3
X_4822_ clknet_leaf_35_clk _0879_ _0072_ VGND VGND VPWR VPWR acc.start sky130_fd_sc_hd__dfrtp_1
XFILLER_61_595 VGND VGND VPWR VPWR sky130_fd_sc_hd__fill_1
XTAP_TAPCELL_ROW_99_1320 VGND VPWR sky130_fd_sc_hd__tapvpwrvgnd_1
X_4753_ clknet_leaf_44_clk _0810_ _0067_ VGND VGND VPWR VPWR lsu.current_store_addr\[21\]
+ sky130_fd_sc_hd__dfrtp_1
X_3704_ _1183_ _1185_ _1182_ VGND VGND VPWR VPWR _1186_ sky130_fd_sc_hd__a21boi_1
X_4684_ clknet_leaf_26_clk _0741_ _0030_ VGND VGND VPWR VPWR lsu.current_load_addr\[14\]
+ sky130_fd_sc_hd__dfrtp_1
X_3635_ net429 VGND VGND VPWR VPWR _0002_ sky130_fd_sc_hd__inv_2
XPHY_EDGE_ROW_96_Right_96 VGND VGND VPWR VPWR sky130_fd_sc_hd__decap_3
X_3566_ net431 VGND VGND VPWR VPWR _0130_ sky130_fd_sc_hd__inv_2
X_2517_ lsu.current_load_addr\[6\] lsu.current_load_addr\[5\] lsu.current_load_addr\[4\]
+ _1921_ VGND VGND VPWR VPWR _1923_ sky130_fd_sc_hd__and4_1
X_3497_ net441 VGND VGND VPWR VPWR _0061_ sky130_fd_sc_hd__inv_2
X_2448_ net85 net269 net238 VGND VGND VPWR VPWR _1877_ sky130_fd_sc_hd__o21a_1
X_2379_ _1808_ _1809_ _1816_ _1817_ _1803_ VGND VGND VPWR VPWR _1818_ sky130_fd_sc_hd__a32o_1
X_4118_ lsu.loader_state\[1\] _1117_ VGND VGND VPWR VPWR _1548_ sky130_fd_sc_hd__nand2_1
X_4049_ net404 _1479_ _1481_ _1484_ _1485_ VGND VGND VPWR VPWR _1486_ sky130_fd_sc_hd__o32a_1
XFILLER_71_337 VGND VGND VPWR VPWR sky130_fd_sc_hd__fill_2
XFILLER_24_242 VGND VGND VPWR VPWR sky130_fd_sc_hd__fill_2
XTAP_TAPCELL_ROW_104_1379 VGND VPWR sky130_fd_sc_hd__tapvpwrvgnd_1
XFILLER_8_419 VGND VGND VPWR VPWR sky130_fd_sc_hd__fill_1
XTAP_TAPCELL_ROW_22_476 VGND VPWR sky130_fd_sc_hd__tapvpwrvgnd_1
XTAP_TAPCELL_ROW_50_785 VGND VPWR sky130_fd_sc_hd__tapvpwrvgnd_1
XFILLER_20_492 VGND VGND VPWR VPWR sky130_fd_sc_hd__fill_1
XFILLER_4_625 VGND VGND VPWR VPWR sky130_fd_sc_hd__fill_2
XFILLER_106_531 VGND VGND VPWR VPWR sky130_fd_sc_hd__fill_1
XFILLER_3_113 VGND VGND VPWR VPWR sky130_fd_sc_hd__decap_4
XFILLER_106_553 VGND VGND VPWR VPWR sky130_fd_sc_hd__decap_3
XTAP_TAPCELL_ROW_72_1025 VGND VPWR sky130_fd_sc_hd__tapvpwrvgnd_1
XTAP_TAPCELL_ROW_58_863 VGND VPWR sky130_fd_sc_hd__tapvpwrvgnd_1
XFILLER_74_197 VGND VGND VPWR VPWR sky130_fd_sc_hd__fill_1
XFILLER_74_85 VGND VGND VPWR VPWR sky130_fd_sc_hd__decap_6
XTAP_TAPCELL_ROW_83_1143 VGND VPWR sky130_fd_sc_hd__tapvpwrvgnd_1
XFILLER_7_485 VPWR VGND VPWR VGND sky130_ef_sc_hd__decap_12
Xhold408 lsu.load_fifo.queue\[3\]\[22\] VGND VGND VPWR VPWR net876 sky130_fd_sc_hd__dlygate4sd3_1
Xhold419 lsu.load_fifo.queue\[5\]\[16\] VGND VGND VPWR VPWR net887 sky130_fd_sc_hd__dlygate4sd3_1
X_3420_ net285 net1153 _2058_ VGND VGND VPWR VPWR _1069_ sky130_fd_sc_hd__mux2_1
XFILLER_99_93 VPWR VGND VPWR VGND sky130_ef_sc_hd__decap_12
XTAP_TAPCELL_ROW_94_1261 VGND VPWR sky130_fd_sc_hd__tapvpwrvgnd_1
X_3351_ net354 net1169 net172 VGND VGND VPWR VPWR _0960_ sky130_fd_sc_hd__mux2_1
XFILLER_97_223 VGND VGND VPWR VPWR sky130_fd_sc_hd__fill_1
X_2302_ net266 _1729_ net240 VGND VGND VPWR VPWR _1755_ sky130_fd_sc_hd__o21ai_1
XFILLER_31_3 VGND VGND VPWR VPWR sky130_fd_sc_hd__fill_1
XFILLER_97_245 VPWR VGND VPWR VGND sky130_ef_sc_hd__decap_12
X_3282_ net803 net275 _2053_ VGND VGND VPWR VPWR _0845_ sky130_fd_sc_hd__mux2_1
X_2233_ net478 net163 _1668_ net262 net243 VGND VGND VPWR VPWR _1705_ sky130_fd_sc_hd__o221a_1
X_5021_ clknet_leaf_55_clk _1076_ _0165_ VGND VGND VPWR VPWR acc.data_out\[0\] sky130_fd_sc_hd__dfrtp_1
X_2164_ lsu.load_counter\[20\] _1568_ _1583_ lsu.load_counter\[19\] VGND VGND VPWR
+ VPWR _1654_ sky130_fd_sc_hd__a22oi_1
X_2095_ lsu.load_counter\[18\] _1574_ _1581_ _1584_ VGND VGND VPWR VPWR _1585_ sky130_fd_sc_hd__o211a_1
XFILLER_19_581 VPWR VGND VPWR VGND sky130_ef_sc_hd__decap_12
XFILLER_53_337 VGND VGND VPWR VPWR sky130_fd_sc_hd__decap_8
XFILLER_0_93 VGND VGND VPWR VPWR sky130_fd_sc_hd__fill_1
X_4805_ clknet_leaf_12_clk _0862_ VGND VGND VPWR VPWR lsu.load_fifo.data_in\[15\]
+ sky130_fd_sc_hd__dfxtp_1
X_2997_ net599 net306 net192 VGND VGND VPWR VPWR _0505_ sky130_fd_sc_hd__mux2_1
X_4736_ clknet_leaf_48_clk _0793_ _0050_ VGND VGND VPWR VPWR lsu.current_store_addr\[4\]
+ sky130_fd_sc_hd__dfrtp_1
X_4667_ clknet_leaf_64_clk _0724_ VGND VGND VPWR VPWR lsu.store_fifo.queue\[15\]\[7\]
+ sky130_fd_sc_hd__dfxtp_1
X_3618_ lsu.load_counter\[12\] VGND VGND VPWR VPWR _1101_ sky130_fd_sc_hd__inv_2
XFILLER_1_617 VPWR VGND VPWR VGND sky130_ef_sc_hd__decap_12
X_4598_ clknet_leaf_2_clk _0655_ VGND VGND VPWR VPWR lsu.load_fifo.queue\[8\]\[14\]
+ sky130_fd_sc_hd__dfxtp_1
X_3549_ net443 VGND VGND VPWR VPWR _0113_ sky130_fd_sc_hd__inv_2
XFILLER_88_289 VGND VGND VPWR VPWR sky130_fd_sc_hd__decap_8
XFILLER_48_109 VGND VGND VPWR VPWR sky130_fd_sc_hd__decap_8
XTAP_TAPCELL_ROW_106_1408 VGND VPWR sky130_fd_sc_hd__tapvpwrvgnd_1
XFILLER_17_529 VPWR VGND VPWR VGND sky130_ef_sc_hd__decap_12
XTAP_TAPCELL_ROW_27_524 VGND VPWR sky130_fd_sc_hd__tapvpwrvgnd_1
XTAP_TAPCELL_ROW_55_833 VGND VPWR sky130_fd_sc_hd__tapvpwrvgnd_1
XFILLER_44_44 VGND VGND VPWR VPWR sky130_fd_sc_hd__fill_1
XFILLER_40_587 VGND VGND VPWR VPWR sky130_fd_sc_hd__fill_1
XFILLER_100_83 VGND VGND VPWR VPWR sky130_fd_sc_hd__fill_1
XFILLER_5_27 VPWR VGND VPWR VGND sky130_ef_sc_hd__decap_12
XFILLER_4_433 VPWR VGND VPWR VGND sky130_ef_sc_hd__decap_12
XFILLER_4_477 VPWR VGND VPWR VGND sky130_ef_sc_hd__decap_12
XFILLER_79_223 VGND VGND VPWR VPWR sky130_fd_sc_hd__fill_1
XFILLER_75_473 VPWR VGND VPWR VGND sky130_ef_sc_hd__decap_12
XFILLER_47_142 VGND VGND VPWR VPWR sky130_fd_sc_hd__decap_6
XFILLER_50_307 VGND VGND VPWR VPWR sky130_fd_sc_hd__fill_1
X_2920_ net902 net325 net221 VGND VGND VPWR VPWR _0432_ sky130_fd_sc_hd__mux2_1
X_2851_ net1034 net333 net222 VGND VGND VPWR VPWR _0362_ sky130_fd_sc_hd__mux2_1
XFILLER_79_3 VGND VGND VPWR VPWR sky130_fd_sc_hd__decap_8
X_2782_ net272 net1225 _2030_ VGND VGND VPWR VPWR _0298_ sky130_fd_sc_hd__mux2_1
X_4521_ clknet_leaf_77_clk _0578_ VGND VGND VPWR VPWR lsu.load_fifo.queue\[1\]\[1\]
+ sky130_fd_sc_hd__dfxtp_1
Xhold205 lsu.load_fifo.queue\[12\]\[29\] VGND VGND VPWR VPWR net673 sky130_fd_sc_hd__dlygate4sd3_1
X_4452_ clknet_leaf_15_clk _0509_ VGND VGND VPWR VPWR lsu.load_fifo.queue\[4\]\[28\]
+ sky130_fd_sc_hd__dfxtp_1
Xhold216 lsu.load_fifo.queue\[11\]\[13\] VGND VGND VPWR VPWR net684 sky130_fd_sc_hd__dlygate4sd3_1
XFILLER_104_309 VGND VGND VPWR VPWR sky130_fd_sc_hd__fill_1
Xhold227 lsu.load_fifo.queue\[11\]\[16\] VGND VGND VPWR VPWR net695 sky130_fd_sc_hd__dlygate4sd3_1
Xhold249 net127 VGND VGND VPWR VPWR net717 sky130_fd_sc_hd__dlygate4sd3_1
Xhold238 lsu.load_fifo.queue\[8\]\[22\] VGND VGND VPWR VPWR net706 sky130_fd_sc_hd__dlygate4sd3_1
X_3403_ net843 net317 net198 VGND VGND VPWR VPWR _1053_ sky130_fd_sc_hd__mux2_1
X_4383_ clknet_leaf_81_clk _0440_ VGND VGND VPWR VPWR lsu.load_fifo.queue\[6\]\[23\]
+ sky130_fd_sc_hd__dfxtp_1
X_3334_ net784 net323 net176 VGND VGND VPWR VPWR _0944_ sky130_fd_sc_hd__mux2_1
X_3265_ lsu.current_store_addr\[14\] net946 net257 VGND VGND VPWR VPWR _0825_ sky130_fd_sc_hd__mux2_1
X_2216_ net167 net164 _1671_ net244 lsu.load_counter\[10\] VGND VGND VPWR VPWR _1695_
+ sky130_fd_sc_hd__o2111a_1
X_5004_ clknet_leaf_68_clk _1059_ VGND VGND VPWR VPWR lsu.load_fifo.queue\[14\]\[25\]
+ sky130_fd_sc_hd__dfxtp_1
X_3196_ net1067 net306 net205 VGND VGND VPWR VPWR _0697_ sky130_fd_sc_hd__mux2_1
X_2147_ lsu.load_counter\[2\] _1635_ VGND VGND VPWR VPWR _1637_ sky130_fd_sc_hd__nand2_1
XFILLER_93_281 VPWR VGND VPWR VGND sky130_ef_sc_hd__decap_12
XFILLER_26_326 VPWR VGND VPWR VGND sky130_ef_sc_hd__decap_12
X_2078_ net14 _1566_ VGND VGND VPWR VPWR _1568_ sky130_fd_sc_hd__xor2_4
XFILLER_81_454 VGND VGND VPWR VPWR sky130_fd_sc_hd__decap_8
XTAP_TAPCELL_ROW_52_803 VGND VPWR sky130_fd_sc_hd__tapvpwrvgnd_1
XTAP_TAPCELL_ROW_101_1338 VGND VPWR sky130_fd_sc_hd__tapvpwrvgnd_1
XTAP_TAPCELL_ROW_32_582 VGND VPWR sky130_fd_sc_hd__tapvpwrvgnd_1
XTAP_TAPCELL_ROW_60_891 VGND VPWR sky130_fd_sc_hd__tapvpwrvgnd_1
X_4719_ clknet_leaf_28_clk _0776_ VGND VGND VPWR VPWR net105 sky130_fd_sc_hd__dfxtp_1
XFILLER_100_6 VPWR VGND VPWR VGND sky130_ef_sc_hd__decap_12
Xhold761 lsu.store_fifo.queue\[7\]\[2\] VGND VGND VPWR VPWR net1229 sky130_fd_sc_hd__dlygate4sd3_1
Xhold750 lsu.load_fifo.queue\[1\]\[15\] VGND VGND VPWR VPWR net1218 sky130_fd_sc_hd__dlygate4sd3_1
Xhold772 net157 VGND VGND VPWR VPWR net1240 sky130_fd_sc_hd__dlygate4sd3_1
Xhold783 net103 VGND VGND VPWR VPWR net1251 sky130_fd_sc_hd__dlygate4sd3_1
XFILLER_1_447 VGND VGND VPWR VPWR sky130_fd_sc_hd__fill_1
Xhold794 acc.byte3\[3\] VGND VGND VPWR VPWR net1262 sky130_fd_sc_hd__dlygate4sd3_1
XTAP_TAPCELL_ROW_4_274 VGND VPWR sky130_fd_sc_hd__tapvpwrvgnd_1
XFILLER_72_421 VPWR VGND VPWR VGND sky130_ef_sc_hd__decap_12
XTAP_TAPCELL_ROW_68_980 VGND VPWR sky130_fd_sc_hd__tapvpwrvgnd_1
XFILLER_17_337 VGND VGND VPWR VPWR sky130_fd_sc_hd__fill_1
XFILLER_55_43 VGND VGND VPWR VPWR sky130_fd_sc_hd__fill_1
XFILLER_57_495 VGND VGND VPWR VPWR sky130_fd_sc_hd__decap_8
XFILLER_44_123 VGND VGND VPWR VPWR sky130_fd_sc_hd__decap_3
XFILLER_55_76 VGND VGND VPWR VPWR sky130_fd_sc_hd__fill_1
XPHY_EDGE_ROW_105_Right_105 VGND VGND VPWR VPWR sky130_fd_sc_hd__decap_3
XFILLER_60_627 VGND VGND VPWR VPWR sky130_fd_sc_hd__decap_3
XTAP_TAPCELL_ROW_80_1113 VGND VPWR sky130_fd_sc_hd__tapvpwrvgnd_1
XFILLER_9_503 VGND VGND VPWR VPWR sky130_fd_sc_hd__fill_1
XTAP_TAPCELL_ROW_78_1086 VGND VPWR sky130_fd_sc_hd__tapvpwrvgnd_1
XTAP_TAPCELL_ROW_91_1231 VGND VPWR sky130_fd_sc_hd__tapvpwrvgnd_1
XFILLER_96_83 VGND VGND VPWR VPWR sky130_fd_sc_hd__fill_1
X_3050_ net552 net335 net208 VGND VGND VPWR VPWR _0555_ sky130_fd_sc_hd__mux2_1
XFILLER_48_473 VGND VGND VPWR VPWR sky130_fd_sc_hd__decap_3
XFILLER_90_240 VPWR VGND VPWR VGND sky130_ef_sc_hd__decap_12
XFILLER_35_167 VGND VGND VPWR VPWR sky130_fd_sc_hd__fill_1
XFILLER_63_498 VGND VGND VPWR VPWR sky130_fd_sc_hd__decap_6
X_3952_ _1399_ _1396_ net359 VGND VGND VPWR VPWR _1400_ sky130_fd_sc_hd__mux2_1
X_2903_ net515 net292 net194 VGND VGND VPWR VPWR _0414_ sky130_fd_sc_hd__mux2_1
X_3883_ net1274 _1340_ net256 VGND VGND VPWR VPWR _1019_ sky130_fd_sc_hd__mux2_1
X_2834_ net299 net1126 net228 VGND VGND VPWR VPWR _0347_ sky130_fd_sc_hd__mux2_1
X_4504_ clknet_leaf_31_clk _0561_ VGND VGND VPWR VPWR lsu.load_fifo.queue\[2\]\[16\]
+ sky130_fd_sc_hd__dfxtp_1
X_2765_ net1109 net282 _2028_ VGND VGND VPWR VPWR _0283_ sky130_fd_sc_hd__mux2_1
X_2696_ net649 net308 net231 VGND VGND VPWR VPWR _0220_ sky130_fd_sc_hd__mux2_1
X_4435_ clknet_leaf_86_clk _0492_ VGND VGND VPWR VPWR lsu.load_fifo.queue\[4\]\[11\]
+ sky130_fd_sc_hd__dfxtp_1
X_4366_ clknet_leaf_0_clk _0423_ VGND VGND VPWR VPWR lsu.load_fifo.queue\[6\]\[6\]
+ sky130_fd_sc_hd__dfxtp_1
XFILLER_98_373 VGND VGND VPWR VPWR sky130_fd_sc_hd__decap_4
X_3317_ net416 net418 _2039_ VGND VGND VPWR VPWR _2055_ sky130_fd_sc_hd__and3_2
X_4297_ clknet_leaf_87_clk _0354_ VGND VGND VPWR VPWR lsu.load_fifo.queue\[10\]\[3\]
+ sky130_fd_sc_hd__dfxtp_1
X_3248_ net666 lsu.current_load_addr\[20\] net237 VGND VGND VPWR VPWR _0786_ sky130_fd_sc_hd__mux2_1
X_3179_ net1037 net340 net205 VGND VGND VPWR VPWR _0680_ sky130_fd_sc_hd__mux2_1
XFILLER_39_484 VGND VGND VPWR VPWR sky130_fd_sc_hd__decap_6
XTAP_TAPCELL_ROW_1_244 VGND VPWR sky130_fd_sc_hd__tapvpwrvgnd_1
XTAP_TAPCELL_ROW_37_641 VGND VPWR sky130_fd_sc_hd__tapvpwrvgnd_1
XTAP_TAPCELL_ROW_65_950 VGND VPWR sky130_fd_sc_hd__tapvpwrvgnd_1
XFILLER_25_35 VGND VGND VPWR VPWR sky130_fd_sc_hd__decap_6
XFILLER_25_57 VPWR VGND VPWR VGND sky130_ef_sc_hd__decap_12
XFILLER_10_513 VPWR VGND VPWR VGND sky130_ef_sc_hd__decap_12
XFILLER_10_557 VPWR VGND VPWR VGND sky130_ef_sc_hd__decap_12
XTAP_TAPCELL_ROW_9_333 VGND VPWR sky130_fd_sc_hd__tapvpwrvgnd_1
XFILLER_9_3 VGND VGND VPWR VPWR sky130_fd_sc_hd__fill_2
Xhold580 lsu.load_fifo.queue\[10\]\[14\] VGND VGND VPWR VPWR net1048 sky130_fd_sc_hd__dlygate4sd3_1
XFILLER_89_362 VPWR VGND VPWR VGND sky130_ef_sc_hd__decap_12
XFILLER_77_502 VGND VGND VPWR VPWR sky130_fd_sc_hd__fill_2
Xhold591 lsu.load_fifo.queue\[9\]\[5\] VGND VGND VPWR VPWR net1059 sky130_fd_sc_hd__dlygate4sd3_1
XFILLER_77_557 VGND VGND VPWR VPWR sky130_fd_sc_hd__decap_3
XFILLER_77_524 VGND VGND VPWR VPWR sky130_fd_sc_hd__decap_4
XFILLER_85_590 VGND VGND VPWR VPWR sky130_fd_sc_hd__decap_6
XFILLER_18_613 VPWR VGND VPWR VGND sky130_ef_sc_hd__decap_12
XFILLER_57_281 VPWR VGND VPWR VGND sky130_ef_sc_hd__decap_12
XFILLER_17_178 VGND VGND VPWR VPWR sky130_fd_sc_hd__fill_2
XFILLER_82_74 VGND VGND VPWR VPWR sky130_fd_sc_hd__fill_1
XFILLER_9_333 VGND VGND VPWR VPWR sky130_fd_sc_hd__decap_3
XTAP_TAPCELL_ROW_43_699 VGND VPWR sky130_fd_sc_hd__tapvpwrvgnd_1
Xoutput107 net107 VGND VGND VPWR VPWR load_addr[12] sky130_fd_sc_hd__buf_2
X_2550_ net260 _1929_ VGND VGND VPWR VPWR _1950_ sky130_fd_sc_hd__nor2_1
Xoutput118 net118 VGND VGND VPWR VPWR load_addr[2] sky130_fd_sc_hd__buf_2
Xoutput129 net129 VGND VGND VPWR VPWR store_addr[11] sky130_fd_sc_hd__buf_2
XFILLER_5_561 VPWR VGND VPWR VGND sky130_ef_sc_hd__decap_12
X_2481_ _1109_ _1898_ _1900_ VGND VGND VPWR VPWR _0794_ sky130_fd_sc_hd__a21oi_1
X_4220_ clknet_leaf_56_clk _0277_ VGND VGND VPWR VPWR lsu.store_fifo.queue\[5\]\[8\]
+ sky130_fd_sc_hd__dfxtp_1
XFILLER_68_557 VPWR VGND VPWR VGND sky130_ef_sc_hd__decap_12
XFILLER_68_524 VGND VGND VPWR VPWR sky130_fd_sc_hd__decap_8
X_4151_ clknet_leaf_1_clk _0208_ VGND VGND VPWR VPWR lsu.load_fifo.queue\[11\]\[11\]
+ sky130_fd_sc_hd__dfxtp_1
XFILLER_83_505 VGND VGND VPWR VPWR sky130_fd_sc_hd__fill_1
X_3102_ net297 net944 net187 VGND VGND VPWR VPWR _0606_ sky130_fd_sc_hd__mux2_1
X_4082_ net403 _1509_ _1511_ _1514_ _1515_ VGND VGND VPWR VPWR _1516_ sky130_fd_sc_hd__o32a_1
X_3033_ net671 net302 net212 VGND VGND VPWR VPWR _0539_ sky130_fd_sc_hd__mux2_1
XFILLER_102_18 VGND VGND VPWR VPWR sky130_fd_sc_hd__decap_8
XFILLER_102_29 VPWR VGND VPWR VGND sky130_ef_sc_hd__decap_12
XTAP_TAPCELL_ROW_34_600 VGND VPWR sky130_fd_sc_hd__tapvpwrvgnd_1
X_4984_ clknet_leaf_4_clk _1039_ VGND VGND VPWR VPWR lsu.load_fifo.queue\[14\]\[5\]
+ sky130_fd_sc_hd__dfxtp_1
X_3935_ lsu.load_fifo.queue\[12\]\[9\] lsu.load_fifo.queue\[13\]\[9\] lsu.load_fifo.queue\[14\]\[9\]
+ lsu.load_fifo.queue\[15\]\[9\] net387 net370 VGND VGND VPWR VPWR _1385_ sky130_fd_sc_hd__mux4_1
X_3866_ lsu.load_fifo.queue\[4\]\[19\] lsu.load_fifo.queue\[5\]\[19\] lsu.load_fifo.queue\[6\]\[19\]
+ lsu.load_fifo.queue\[7\]\[19\] net385 net368 VGND VGND VPWR VPWR _1326_ sky130_fd_sc_hd__mux4_1
X_3797_ lsu.load_fifo.queue\[0\]\[29\] lsu.load_fifo.queue\[1\]\[29\] lsu.load_fifo.queue\[2\]\[29\]
+ lsu.load_fifo.queue\[3\]\[29\] net394 net377 VGND VGND VPWR VPWR _1267_ sky130_fd_sc_hd__mux4_1
X_2817_ net333 net1149 net226 VGND VGND VPWR VPWR _0330_ sky130_fd_sc_hd__mux2_1
X_2748_ net746 net272 _2026_ VGND VGND VPWR VPWR _0268_ sky130_fd_sc_hd__mux2_1
XFILLER_105_404 VGND VGND VPWR VPWR sky130_fd_sc_hd__fill_1
X_2679_ net1036 net342 net230 VGND VGND VPWR VPWR _0203_ sky130_fd_sc_hd__mux2_1
X_4418_ clknet_leaf_6_clk _0475_ VGND VGND VPWR VPWR lsu.load_fifo.queue\[5\]\[26\]
+ sky130_fd_sc_hd__dfxtp_1
Xfanout323 lsu.load_fifo.data_in\[16\] VGND VGND VPWR VPWR net323 sky130_fd_sc_hd__dlymetal6s2s_1
Xfanout312 net313 VGND VGND VPWR VPWR net312 sky130_fd_sc_hd__clkbuf_2
Xfanout301 lsu.load_fifo.data_in\[27\] VGND VGND VPWR VPWR net301 sky130_fd_sc_hd__buf_1
Xfanout334 lsu.load_fifo.data_in\[10\] VGND VGND VPWR VPWR net334 sky130_fd_sc_hd__clkbuf_2
X_4349_ clknet_leaf_81_clk _0406_ VGND VGND VPWR VPWR lsu.load_fifo.queue\[7\]\[23\]
+ sky130_fd_sc_hd__dfxtp_1
Xfanout356 lsu.load_fifo.r_ptr\[3\] VGND VGND VPWR VPWR net356 sky130_fd_sc_hd__buf_4
Xfanout345 lsu.load_fifo.data_in\[5\] VGND VGND VPWR VPWR net345 sky130_fd_sc_hd__buf_1
XFILLER_86_365 VPWR VGND VPWR VGND sky130_ef_sc_hd__decap_12
Xfanout367 net369 VGND VGND VPWR VPWR net367 sky130_fd_sc_hd__buf_2
Xfanout389 net390 VGND VGND VPWR VPWR net389 sky130_fd_sc_hd__buf_4
Xfanout378 net381 VGND VGND VPWR VPWR net378 sky130_fd_sc_hd__clkbuf_4
XFILLER_36_67 VGND VGND VPWR VPWR sky130_fd_sc_hd__fill_1
XFILLER_54_251 VGND VGND VPWR VPWR sky130_fd_sc_hd__fill_1
XTAP_TAPCELL_ROW_40_669 VGND VPWR sky130_fd_sc_hd__tapvpwrvgnd_1
XFILLER_52_99 VGND VGND VPWR VPWR sky130_fd_sc_hd__decap_6
XFILLER_10_365 VGND VGND VPWR VPWR sky130_fd_sc_hd__fill_1
XTAP_TAPCELL_ROW_75_1056 VGND VPWR sky130_fd_sc_hd__tapvpwrvgnd_1
XFILLER_2_531 VGND VGND VPWR VPWR sky130_fd_sc_hd__fill_1
XFILLER_89_181 VGND VGND VPWR VPWR sky130_fd_sc_hd__fill_2
XFILLER_77_63 VGND VGND VPWR VPWR sky130_fd_sc_hd__fill_1
XFILLER_77_41 VGND VGND VPWR VPWR sky130_fd_sc_hd__decap_6
XFILLER_18_410 VGND VGND VPWR VPWR sky130_fd_sc_hd__decap_8
XFILLER_65_538 VGND VGND VPWR VPWR sky130_fd_sc_hd__fill_2
XFILLER_93_51 VGND VGND VPWR VPWR sky130_fd_sc_hd__decap_4
XFILLER_18_421 VGND VGND VPWR VPWR sky130_fd_sc_hd__decap_6
XTAP_TAPCELL_ROW_48_758 VGND VPWR sky130_fd_sc_hd__tapvpwrvgnd_1
XFILLER_73_571 VGND VGND VPWR VPWR sky130_fd_sc_hd__decap_3
XTAP_TAPCELL_ROW_86_1174 VGND VPWR sky130_fd_sc_hd__tapvpwrvgnd_1
XFILLER_33_457 VGND VGND VPWR VPWR sky130_fd_sc_hd__decap_8
XFILLER_60_243 VGND VGND VPWR VPWR sky130_fd_sc_hd__fill_1
X_3720_ _1199_ _1201_ _1198_ VGND VGND VPWR VPWR _1202_ sky130_fd_sc_hd__a21boi_1
Xclkbuf_leaf_40_clk clknet_3_6__leaf_clk VGND VGND VPWR VPWR clknet_leaf_40_clk sky130_fd_sc_hd__clkbuf_8
X_3651_ acc.byte1\[5\] acc.byte0\[5\] VGND VGND VPWR VPWR _1133_ sky130_fd_sc_hd__nand2_1
X_2602_ lsu.current_load_addr\[2\] _1988_ net476 VGND VGND VPWR VPWR _0729_ sky130_fd_sc_hd__mux2_4
X_3582_ net422 VGND VGND VPWR VPWR _0146_ sky130_fd_sc_hd__inv_2
X_2533_ net166 net163 _1937_ net243 VGND VGND VPWR VPWR _1938_ sky130_fd_sc_hd__o211a_1
XTAP_TAPCELL_ROW_97_1292 VGND VPWR sky130_fd_sc_hd__tapvpwrvgnd_1
XFILLER_5_391 VGND VGND VPWR VPWR sky130_fd_sc_hd__fill_1
XFILLER_102_418 VGND VGND VPWR VPWR sky130_fd_sc_hd__fill_2
X_2464_ _1884_ _1888_ _1887_ net1311 VGND VGND VPWR VPWR _0799_ sky130_fd_sc_hd__o2bb2a_1
XFILLER_102_429 VGND VGND VPWR VPWR sky130_fd_sc_hd__fill_2
X_2395_ _1781_ _1833_ net197 _1570_ lsu.store_counter\[22\] VGND VGND VPWR VPWR _1834_
+ sky130_fd_sc_hd__a32o_1
X_4203_ clknet_leaf_70_clk _0260_ VGND VGND VPWR VPWR lsu.store_fifo.queue\[6\]\[1\]
+ sky130_fd_sc_hd__dfxtp_1
XFILLER_68_354 VGND VGND VPWR VPWR sky130_fd_sc_hd__fill_1
X_4134_ clknet_leaf_60_clk _0191_ VGND VGND VPWR VPWR lsu.store_fifo.queue\[10\]\[4\]
+ sky130_fd_sc_hd__dfxtp_1
XFILLER_3_93 VGND VGND VPWR VPWR sky130_fd_sc_hd__decap_3
XFILLER_28_218 VGND VGND VPWR VPWR sky130_fd_sc_hd__fill_2
XFILLER_56_527 VGND VGND VPWR VPWR sky130_fd_sc_hd__decap_4
X_4065_ lsu.store_fifo.queue\[8\]\[4\] lsu.store_fifo.queue\[9\]\[4\] lsu.store_fifo.queue\[10\]\[4\]
+ lsu.store_fifo.queue\[11\]\[4\] net414 net410 VGND VGND VPWR VPWR _1500_ sky130_fd_sc_hd__mux4_1
X_3016_ net564 net336 net210 VGND VGND VPWR VPWR _0522_ sky130_fd_sc_hd__mux2_1
X_4967_ clknet_leaf_9_clk _1022_ _0153_ VGND VGND VPWR VPWR acc.byte2\[4\] sky130_fd_sc_hd__dfrtp_1
Xclkbuf_leaf_31_clk clknet_3_3__leaf_clk VGND VGND VPWR VPWR clknet_leaf_31_clk sky130_fd_sc_hd__clkbuf_8
X_4898_ clknet_leaf_68_clk _0953_ VGND VGND VPWR VPWR lsu.load_fifo.queue\[12\]\[25\]
+ sky130_fd_sc_hd__dfxtp_1
X_3918_ lsu.load_fifo.queue\[8\]\[11\] lsu.load_fifo.queue\[9\]\[11\] lsu.load_fifo.queue\[10\]\[11\]
+ lsu.load_fifo.queue\[11\]\[11\] net384 net367 VGND VGND VPWR VPWR _1370_ sky130_fd_sc_hd__mux4_1
X_3849_ _1311_ _1310_ net362 VGND VGND VPWR VPWR _1312_ sky130_fd_sc_hd__mux2_1
XFILLER_98_29 VPWR VGND VPWR VGND sky130_ef_sc_hd__decap_12
Xfanout164 net165 VGND VGND VPWR VPWR net164 sky130_fd_sc_hd__buf_6
XFILLER_101_484 VGND VGND VPWR VPWR sky130_fd_sc_hd__decap_8
Xfanout175 _2055_ VGND VGND VPWR VPWR net175 sky130_fd_sc_hd__buf_4
Xfanout186 _2044_ VGND VGND VPWR VPWR net186 sky130_fd_sc_hd__buf_2
XFILLER_86_195 VGND VGND VPWR VPWR sky130_fd_sc_hd__fill_1
XTAP_TAPCELL_ROW_17_419 VGND VPWR sky130_fd_sc_hd__tapvpwrvgnd_1
XTAP_TAPCELL_ROW_45_728 VGND VPWR sky130_fd_sc_hd__tapvpwrvgnd_1
XFILLER_15_413 VPWR VGND VPWR VGND sky130_ef_sc_hd__decap_12
XFILLER_42_243 VGND VGND VPWR VPWR sky130_fd_sc_hd__fill_2
Xclkbuf_leaf_22_clk clknet_3_2__leaf_clk VGND VGND VPWR VPWR clknet_leaf_22_clk sky130_fd_sc_hd__clkbuf_8
X_2180_ lsu.load_counter\[7\] lsu.load_counter\[6\] _1669_ VGND VGND VPWR VPWR _1670_
+ sky130_fd_sc_hd__and3_1
XFILLER_2_394 VPWR VGND VPWR VGND sky130_ef_sc_hd__decap_12
XTAP_TAPCELL_ROW_88_1203 VGND VPWR sky130_fd_sc_hd__tapvpwrvgnd_1
XFILLER_92_121 VPWR VGND VPWR VGND sky130_ef_sc_hd__decap_12
XFILLER_92_176 VPWR VGND VPWR VGND sky130_ef_sc_hd__decap_12
XFILLER_73_390 VGND VGND VPWR VPWR sky130_fd_sc_hd__fill_2
X_4821_ clknet_leaf_81_clk _0878_ VGND VGND VPWR VPWR lsu.load_fifo.data_in\[31\]
+ sky130_fd_sc_hd__dfxtp_1
XFILLER_61_541 VGND VGND VPWR VPWR sky130_fd_sc_hd__fill_1
X_4752_ clknet_leaf_44_clk _0809_ _0066_ VGND VGND VPWR VPWR lsu.current_store_addr\[20\]
+ sky130_fd_sc_hd__dfrtp_1
XFILLER_21_449 VGND VGND VPWR VPWR sky130_fd_sc_hd__fill_2
Xclkbuf_leaf_13_clk clknet_3_3__leaf_clk VGND VGND VPWR VPWR clknet_leaf_13_clk sky130_fd_sc_hd__clkbuf_8
XTAP_TAPCELL_ROW_99_1321 VGND VPWR sky130_fd_sc_hd__tapvpwrvgnd_1
X_4683_ clknet_leaf_25_clk _0740_ _0029_ VGND VGND VPWR VPWR lsu.current_load_addr\[13\]
+ sky130_fd_sc_hd__dfrtp_1
X_3703_ _1149_ _1151_ VGND VGND VPWR VPWR _1185_ sky130_fd_sc_hd__xnor2_1
X_3634_ lsu.loader_state\[0\] VGND VGND VPWR VPWR _1117_ sky130_fd_sc_hd__inv_2
X_3565_ net433 VGND VGND VPWR VPWR _0129_ sky130_fd_sc_hd__inv_2
X_2516_ lsu.current_load_addr\[4\] _1921_ VGND VGND VPWR VPWR _1922_ sky130_fd_sc_hd__nand2_1
X_3496_ net432 VGND VGND VPWR VPWR _0060_ sky130_fd_sc_hd__inv_2
X_2447_ _1852_ _1875_ net269 VGND VGND VPWR VPWR _1876_ sky130_fd_sc_hd__o21ai_1
X_2378_ _1804_ _1805_ _1806_ _1802_ VGND VGND VPWR VPWR _1817_ sky130_fd_sc_hd__a31o_1
XPHY_EDGE_ROW_3_Left_110 VGND VGND VPWR VPWR sky130_fd_sc_hd__decap_3
X_4117_ _1116_ lsu.loader_state\[0\] VGND VGND VPWR VPWR _1547_ sky130_fd_sc_hd__nor2_1
XFILLER_83_143 VGND VGND VPWR VPWR sky130_fd_sc_hd__fill_1
X_4048_ net401 _1482_ net404 VGND VGND VPWR VPWR _1485_ sky130_fd_sc_hd__o21ai_1
XFILLER_37_571 VGND VGND VPWR VPWR sky130_fd_sc_hd__fill_2
XTAP_TAPCELL_ROW_104_1369 VGND VPWR sky130_fd_sc_hd__tapvpwrvgnd_1
XTAP_TAPCELL_ROW_22_477 VGND VPWR sky130_fd_sc_hd__tapvpwrvgnd_1
XPHY_EDGE_ROW_49_Left_156 VGND VGND VPWR VPWR sky130_fd_sc_hd__decap_3
XTAP_TAPCELL_ROW_50_775 VGND VPWR sky130_fd_sc_hd__tapvpwrvgnd_1
XFILLER_106_587 VGND VGND VPWR VPWR sky130_fd_sc_hd__fill_1
XTAP_TAPCELL_ROW_72_1026 VGND VPWR sky130_fd_sc_hd__tapvpwrvgnd_1
XFILLER_58_54 VGND VGND VPWR VPWR sky130_fd_sc_hd__decap_4
XFILLER_94_419 VGND VGND VPWR VPWR sky130_fd_sc_hd__fill_1
XPHY_EDGE_ROW_58_Left_165 VGND VGND VPWR VPWR sky130_fd_sc_hd__decap_3
XFILLER_59_151 VGND VGND VPWR VPWR sky130_fd_sc_hd__decap_8
XFILLER_59_173 VGND VGND VPWR VPWR sky130_fd_sc_hd__fill_1
XTAP_TAPCELL_ROW_58_864 VGND VPWR sky130_fd_sc_hd__tapvpwrvgnd_1
XFILLER_15_210 VGND VGND VPWR VPWR sky130_fd_sc_hd__decap_4
XTAP_TAPCELL_ROW_83_1144 VGND VPWR sky130_fd_sc_hd__tapvpwrvgnd_1
XFILLER_70_360 VGND VGND VPWR VPWR sky130_fd_sc_hd__decap_4
XFILLER_90_41 VPWR VGND VPWR VGND sky130_ef_sc_hd__decap_12
XFILLER_30_224 VGND VGND VPWR VPWR sky130_fd_sc_hd__decap_4
XPHY_EDGE_ROW_67_Left_174 VGND VGND VPWR VPWR sky130_fd_sc_hd__decap_3
XFILLER_90_85 VPWR VGND VPWR VGND sky130_ef_sc_hd__decap_12
Xhold409 lsu.load_fifo.queue\[12\]\[22\] VGND VGND VPWR VPWR net877 sky130_fd_sc_hd__dlygate4sd3_1
XFILLER_7_497 VGND VGND VPWR VPWR sky130_fd_sc_hd__decap_6
XTAP_TAPCELL_ROW_94_1262 VGND VPWR sky130_fd_sc_hd__tapvpwrvgnd_1
X_3350_ net417 net419 _2003_ VGND VGND VPWR VPWR _2056_ sky130_fd_sc_hd__nand3_4
X_2301_ _1752_ _1754_ VGND VGND VPWR VPWR _0891_ sky130_fd_sc_hd__and2_1
XFILLER_97_257 VPWR VGND VPWR VGND sky130_ef_sc_hd__decap_12
XPHY_EDGE_ROW_76_Left_183 VGND VGND VPWR VPWR sky130_fd_sc_hd__decap_3
X_3281_ net1145 net276 _2053_ VGND VGND VPWR VPWR _0844_ sky130_fd_sc_hd__mux2_1
X_5020_ clknet_leaf_65_clk _1075_ VGND VGND VPWR VPWR lsu.store_fifo.queue\[13\]\[9\]
+ sky130_fd_sc_hd__dfxtp_1
X_2232_ net1298 _1704_ _1702_ VGND VGND VPWR VPWR _0910_ sky130_fd_sc_hd__o21ba_1
XFILLER_24_3 VGND VGND VPWR VPWR sky130_fd_sc_hd__fill_2
Xclkbuf_leaf_2_clk clknet_3_0__leaf_clk VGND VGND VPWR VPWR clknet_leaf_2_clk sky130_fd_sc_hd__clkbuf_8
X_2163_ _1648_ _1651_ _1652_ VGND VGND VPWR VPWR _1653_ sky130_fd_sc_hd__a21bo_1
XFILLER_65_121 VGND VGND VPWR VPWR sky130_fd_sc_hd__decap_4
X_2094_ _1583_ lsu.load_counter\[19\] VGND VGND VPWR VPWR _1584_ sky130_fd_sc_hd__or2_4
XFILLER_80_102 VGND VGND VPWR VPWR sky130_fd_sc_hd__decap_6
XFILLER_19_593 VPWR VGND VPWR VGND sky130_ef_sc_hd__decap_12
XPHY_EDGE_ROW_85_Left_192 VGND VGND VPWR VPWR sky130_fd_sc_hd__decap_3
X_4804_ clknet_leaf_3_clk _0861_ VGND VGND VPWR VPWR lsu.load_fifo.data_in\[14\] sky130_fd_sc_hd__dfxtp_1
XFILLER_61_393 VGND VGND VPWR VPWR sky130_fd_sc_hd__decap_3
X_4735_ clknet_leaf_46_clk _0792_ _0049_ VGND VGND VPWR VPWR lsu.current_store_addr\[3\]
+ sky130_fd_sc_hd__dfrtp_1
X_2996_ net568 net309 net190 VGND VGND VPWR VPWR _0504_ sky130_fd_sc_hd__mux2_1
X_4666_ clknet_leaf_49_clk _0723_ VGND VGND VPWR VPWR lsu.store_fifo.queue\[15\]\[6\]
+ sky130_fd_sc_hd__dfxtp_1
X_3617_ lsu.load_counter\[14\] VGND VGND VPWR VPWR _1100_ sky130_fd_sc_hd__inv_2
X_4597_ clknet_leaf_2_clk _0654_ VGND VGND VPWR VPWR lsu.load_fifo.queue\[8\]\[13\]
+ sky130_fd_sc_hd__dfxtp_1
X_3548_ net439 VGND VGND VPWR VPWR _0112_ sky130_fd_sc_hd__inv_2
XFILLER_103_513 VGND VGND VPWR VPWR sky130_fd_sc_hd__decap_4
XFILLER_88_213 VPWR VGND VPWR VGND sky130_ef_sc_hd__decap_12
XFILLER_1_629 VGND VGND VPWR VPWR sky130_fd_sc_hd__fill_1
X_3479_ net440 VGND VGND VPWR VPWR _0043_ sky130_fd_sc_hd__inv_2
XFILLER_76_419 VGND VGND VPWR VPWR sky130_fd_sc_hd__fill_1
XFILLER_29_302 VGND VGND VPWR VPWR sky130_fd_sc_hd__decap_3
XFILLER_29_335 VGND VGND VPWR VPWR sky130_fd_sc_hd__fill_1
XTAP_TAPCELL_ROW_106_1409 VGND VPWR sky130_fd_sc_hd__tapvpwrvgnd_1
XTAP_TAPCELL_ROW_27_525 VGND VPWR sky130_fd_sc_hd__tapvpwrvgnd_1
XTAP_TAPCELL_ROW_55_834 VGND VPWR sky130_fd_sc_hd__tapvpwrvgnd_1
XFILLER_44_23 VGND VGND VPWR VPWR sky130_fd_sc_hd__decap_4
XFILLER_8_206 VGND VGND VPWR VPWR sky130_fd_sc_hd__fill_2
XFILLER_4_401 VPWR VGND VPWR VGND sky130_ef_sc_hd__decap_12
XFILLER_5_39 VGND VGND VPWR VPWR sky130_fd_sc_hd__decap_4
XFILLER_4_445 VPWR VGND VPWR VGND sky130_ef_sc_hd__decap_12
XFILLER_4_489 VPWR VGND VPWR VGND sky130_ef_sc_hd__decap_12
XFILLER_47_121 VGND VGND VPWR VPWR sky130_fd_sc_hd__decap_3
XFILLER_47_154 VGND VGND VPWR VPWR sky130_fd_sc_hd__decap_6
XFILLER_75_485 VPWR VGND VPWR VGND sky130_ef_sc_hd__decap_12
XFILLER_90_477 VPWR VGND VPWR VGND sky130_ef_sc_hd__decap_12
X_2850_ net612 net334 net224 VGND VGND VPWR VPWR _0361_ sky130_fd_sc_hd__mux2_1
XFILLER_31_522 VGND VGND VPWR VPWR sky130_fd_sc_hd__fill_1
XFILLER_43_393 VGND VGND VPWR VPWR sky130_fd_sc_hd__decap_8
X_2781_ net274 net1211 _2030_ VGND VGND VPWR VPWR _0297_ sky130_fd_sc_hd__mux2_1
X_4520_ clknet_leaf_35_clk _0577_ VGND VGND VPWR VPWR lsu.load_fifo.queue\[1\]\[0\]
+ sky130_fd_sc_hd__dfxtp_1
X_4451_ clknet_leaf_81_clk _0508_ VGND VGND VPWR VPWR lsu.load_fifo.queue\[4\]\[27\]
+ sky130_fd_sc_hd__dfxtp_1
Xhold206 lsu.load_fifo.queue\[0\]\[19\] VGND VGND VPWR VPWR net674 sky130_fd_sc_hd__dlygate4sd3_1
Xhold217 lsu.store_fifo.queue\[12\]\[2\] VGND VGND VPWR VPWR net685 sky130_fd_sc_hd__dlygate4sd3_1
Xhold239 net105 VGND VGND VPWR VPWR net707 sky130_fd_sc_hd__dlygate4sd3_1
Xhold228 lsu.load_fifo.queue\[4\]\[20\] VGND VGND VPWR VPWR net696 sky130_fd_sc_hd__dlygate4sd3_1
X_3402_ net1102 net318 net198 VGND VGND VPWR VPWR _1052_ sky130_fd_sc_hd__mux2_1
XFILLER_98_533 VGND VGND VPWR VPWR sky130_fd_sc_hd__fill_2
X_4382_ clknet_leaf_75_clk _0439_ VGND VGND VPWR VPWR lsu.load_fifo.queue\[6\]\[22\]
+ sky130_fd_sc_hd__dfxtp_1
X_3333_ net1025 net324 net175 VGND VGND VPWR VPWR _0943_ sky130_fd_sc_hd__mux2_1
XFILLER_105_18 VPWR VGND VPWR VGND sky130_ef_sc_hd__decap_12
XPHY_EDGE_ROW_7_Right_7 VGND VGND VPWR VPWR sky130_fd_sc_hd__decap_3
XFILLER_58_419 VGND VGND VPWR VPWR sky130_fd_sc_hd__fill_1
X_3264_ lsu.current_store_addr\[13\] net1170 net257 VGND VGND VPWR VPWR _0824_ sky130_fd_sc_hd__mux2_1
X_2215_ _1101_ _1693_ _1694_ net483 VGND VGND VPWR VPWR _0917_ sky130_fd_sc_hd__a2bb2o_1
X_5003_ clknet_leaf_30_clk _1058_ VGND VGND VPWR VPWR lsu.load_fifo.queue\[14\]\[24\]
+ sky130_fd_sc_hd__dfxtp_1
X_3195_ net920 net308 net203 VGND VGND VPWR VPWR _0696_ sky130_fd_sc_hd__mux2_1
X_2146_ lsu.load_counter\[3\] _1633_ _1635_ lsu.load_counter\[2\] VGND VGND VPWR VPWR
+ _1636_ sky130_fd_sc_hd__o22a_1
XFILLER_26_338 VPWR VGND VPWR VGND sky130_ef_sc_hd__decap_12
XFILLER_53_113 VGND VGND VPWR VPWR sky130_fd_sc_hd__fill_2
X_2077_ net14 net12 net11 _1565_ VGND VGND VPWR VPWR _1567_ sky130_fd_sc_hd__or4_4
XFILLER_93_293 VPWR VGND VPWR VGND sky130_ef_sc_hd__decap_12
XPHY_EDGE_ROW_93_Left_200 VGND VGND VPWR VPWR sky130_fd_sc_hd__decap_3
XFILLER_53_146 VPWR VGND VPWR VGND sky130_ef_sc_hd__decap_12
XFILLER_81_488 VGND VGND VPWR VPWR sky130_fd_sc_hd__decap_8
XTAP_TAPCELL_ROW_52_804 VGND VPWR sky130_fd_sc_hd__tapvpwrvgnd_1
XTAP_TAPCELL_ROW_101_1339 VGND VPWR sky130_fd_sc_hd__tapvpwrvgnd_1
X_2979_ net797 net342 net189 VGND VGND VPWR VPWR _0487_ sky130_fd_sc_hd__mux2_1
XTAP_TAPCELL_ROW_32_583 VGND VPWR sky130_fd_sc_hd__tapvpwrvgnd_1
XTAP_TAPCELL_ROW_60_892 VGND VPWR sky130_fd_sc_hd__tapvpwrvgnd_1
X_4718_ clknet_leaf_29_clk net773 VGND VGND VPWR VPWR net125 sky130_fd_sc_hd__dfxtp_1
X_4649_ clknet_leaf_51_clk _0706_ _0005_ VGND VGND VPWR VPWR lsu.store_fifo.w_ptr\[1\]
+ sky130_fd_sc_hd__dfrtp_1
Xhold762 lsu.load_fifo.queue\[5\]\[14\] VGND VGND VPWR VPWR net1230 sky130_fd_sc_hd__dlygate4sd3_1
Xhold773 net156 VGND VGND VPWR VPWR net1241 sky130_fd_sc_hd__dlygate4sd3_1
Xhold751 lsu.load_fifo.queue\[13\]\[19\] VGND VGND VPWR VPWR net1219 sky130_fd_sc_hd__dlygate4sd3_1
Xhold740 net144 VGND VGND VPWR VPWR net1208 sky130_fd_sc_hd__dlygate4sd3_1
Xhold784 lsu.load_fifo.data_in\[1\] VGND VGND VPWR VPWR net1252 sky130_fd_sc_hd__dlygate4sd3_1
Xhold795 acc.byte2\[7\] VGND VGND VPWR VPWR net1263 sky130_fd_sc_hd__dlygate4sd3_1
XFILLER_39_67 VGND VGND VPWR VPWR sky130_fd_sc_hd__fill_1
XTAP_TAPCELL_ROW_4_275 VGND VPWR sky130_fd_sc_hd__tapvpwrvgnd_1
XFILLER_72_411 VGND VGND VPWR VPWR sky130_fd_sc_hd__decap_8
XTAP_TAPCELL_ROW_68_981 VGND VPWR sky130_fd_sc_hd__tapvpwrvgnd_1
XFILLER_72_433 VPWR VGND VPWR VGND sky130_ef_sc_hd__decap_12
XFILLER_72_477 VPWR VGND VPWR VGND sky130_ef_sc_hd__decap_12
XTAP_TAPCELL_ROW_80_1114 VGND VPWR sky130_fd_sc_hd__tapvpwrvgnd_1
XFILLER_25_393 VGND VGND VPWR VPWR sky130_fd_sc_hd__decap_8
XFILLER_40_330 VGND VGND VPWR VPWR sky130_fd_sc_hd__decap_3
XFILLER_40_363 VGND VGND VPWR VPWR sky130_fd_sc_hd__fill_1
XFILLER_9_559 VGND VGND VPWR VPWR sky130_fd_sc_hd__fill_1
XTAP_TAPCELL_ROW_78_1087 VGND VPWR sky130_fd_sc_hd__tapvpwrvgnd_1
XTAP_TAPCELL_ROW_91_1232 VGND VPWR sky130_fd_sc_hd__tapvpwrvgnd_1
XFILLER_4_286 VGND VGND VPWR VPWR sky130_fd_sc_hd__decap_4
XFILLER_67_216 VGND VGND VPWR VPWR sky130_fd_sc_hd__decap_8
XFILLER_67_249 VGND VGND VPWR VPWR sky130_fd_sc_hd__decap_6
X_3951_ _1398_ _1397_ net365 VGND VGND VPWR VPWR _1399_ sky130_fd_sc_hd__mux2_1
XFILLER_16_360 VGND VGND VPWR VPWR sky130_fd_sc_hd__decap_4
XFILLER_51_617 VGND VGND VPWR VPWR sky130_fd_sc_hd__fill_1
X_2902_ net782 net294 net195 VGND VGND VPWR VPWR _0413_ sky130_fd_sc_hd__mux2_1
XFILLER_91_3 VPWR VGND VPWR VGND sky130_ef_sc_hd__decap_12
X_3882_ _1337_ _1339_ _1336_ _1338_ net357 net361 VGND VGND VPWR VPWR _1340_ sky130_fd_sc_hd__mux4_1
X_2833_ net301 net1134 net227 VGND VGND VPWR VPWR _0346_ sky130_fd_sc_hd__mux2_1
X_2764_ net1189 net284 _2028_ VGND VGND VPWR VPWR _0282_ sky130_fd_sc_hd__mux2_1
XFILLER_8_581 VGND VGND VPWR VPWR sky130_fd_sc_hd__decap_6
X_4503_ clknet_leaf_11_clk _0560_ VGND VGND VPWR VPWR lsu.load_fifo.queue\[2\]\[15\]
+ sky130_fd_sc_hd__dfxtp_1
X_2695_ net831 net311 net231 VGND VGND VPWR VPWR _0219_ sky130_fd_sc_hd__mux2_1
X_4434_ clknet_leaf_21_clk _0491_ VGND VGND VPWR VPWR lsu.load_fifo.queue\[4\]\[10\]
+ sky130_fd_sc_hd__dfxtp_1
X_4365_ clknet_leaf_5_clk _0422_ VGND VGND VPWR VPWR lsu.load_fifo.queue\[6\]\[5\]
+ sky130_fd_sc_hd__dfxtp_1
X_3316_ lsu.load_fifo.data_in\[31\] net71 net249 VGND VGND VPWR VPWR _0878_ sky130_fd_sc_hd__mux2_1
X_4296_ clknet_leaf_21_clk _0353_ VGND VGND VPWR VPWR lsu.load_fifo.queue\[10\]\[2\]
+ sky130_fd_sc_hd__dfxtp_1
X_3247_ net557 lsu.current_load_addr\[19\] net237 VGND VGND VPWR VPWR _0785_ sky130_fd_sc_hd__mux2_1
XFILLER_100_357 VGND VGND VPWR VPWR sky130_fd_sc_hd__decap_6
X_3178_ net558 net342 net202 VGND VGND VPWR VPWR _0679_ sky130_fd_sc_hd__mux2_1
X_2129_ net21 _1618_ _1556_ VGND VGND VPWR VPWR _1619_ sky130_fd_sc_hd__a21boi_2
XTAP_TAPCELL_ROW_1_245 VGND VPWR sky130_fd_sc_hd__tapvpwrvgnd_1
XTAP_TAPCELL_ROW_37_642 VGND VPWR sky130_fd_sc_hd__tapvpwrvgnd_1
XFILLER_54_433 VGND VGND VPWR VPWR sky130_fd_sc_hd__fill_1
XTAP_TAPCELL_ROW_65_940 VGND VPWR sky130_fd_sc_hd__tapvpwrvgnd_1
XFILLER_81_241 VGND VGND VPWR VPWR sky130_fd_sc_hd__fill_2
XFILLER_54_477 VGND VGND VPWR VPWR sky130_fd_sc_hd__decap_6
XFILLER_25_69 VGND VGND VPWR VPWR sky130_fd_sc_hd__decap_3
XFILLER_22_330 VGND VGND VPWR VPWR sky130_fd_sc_hd__fill_2
XFILLER_22_341 VGND VGND VPWR VPWR sky130_fd_sc_hd__decap_6
XFILLER_10_525 VGND VGND VPWR VPWR sky130_fd_sc_hd__decap_6
XFILLER_10_569 VPWR VGND VPWR VGND sky130_ef_sc_hd__decap_12
XFILLER_41_57 VGND VGND VPWR VPWR sky130_fd_sc_hd__fill_1
XTAP_TAPCELL_ROW_9_334 VGND VPWR sky130_fd_sc_hd__tapvpwrvgnd_1
XFILLER_89_341 VGND VGND VPWR VPWR sky130_fd_sc_hd__decap_3
Xhold570 lsu.load_fifo.queue\[12\]\[24\] VGND VGND VPWR VPWR net1038 sky130_fd_sc_hd__dlygate4sd3_1
Xhold581 lsu.load_fifo.queue\[9\]\[1\] VGND VGND VPWR VPWR net1049 sky130_fd_sc_hd__dlygate4sd3_1
XFILLER_103_151 VGND VGND VPWR VPWR sky130_fd_sc_hd__fill_1
XFILLER_89_374 VPWR VGND VPWR VGND sky130_ef_sc_hd__decap_12
Xhold592 lsu.load_fifo.queue\[0\]\[23\] VGND VGND VPWR VPWR net1060 sky130_fd_sc_hd__dlygate4sd3_1
XFILLER_2_29 VPWR VGND VPWR VGND sky130_ef_sc_hd__decap_12
XFILLER_18_625 VGND VGND VPWR VPWR sky130_fd_sc_hd__decap_4
XFILLER_17_113 VGND VGND VPWR VPWR sky130_fd_sc_hd__decap_6
XFILLER_57_293 VPWR VGND VPWR VGND sky130_ef_sc_hd__decap_12
XFILLER_9_345 VGND VGND VPWR VPWR sky130_fd_sc_hd__fill_2
Xoutput119 net119 VGND VGND VPWR VPWR load_addr[3] sky130_fd_sc_hd__buf_2
Xoutput108 net108 VGND VGND VPWR VPWR load_addr[13] sky130_fd_sc_hd__buf_2
XFILLER_99_105 VGND VGND VPWR VPWR sky130_fd_sc_hd__decap_6
XFILLER_5_573 VPWR VGND VPWR VGND sky130_ef_sc_hd__decap_12
X_2480_ net265 _1845_ _1899_ net238 VGND VGND VPWR VPWR _1900_ sky130_fd_sc_hd__o211a_1
XFILLER_56_6 VGND VGND VPWR VPWR sky130_fd_sc_hd__decap_8
X_4150_ clknet_leaf_24_clk _0207_ VGND VGND VPWR VPWR lsu.load_fifo.queue\[11\]\[10\]
+ sky130_fd_sc_hd__dfxtp_1
X_3101_ net298 net1065 net187 VGND VGND VPWR VPWR _0605_ sky130_fd_sc_hd__mux2_1
XFILLER_68_569 VGND VGND VPWR VPWR sky130_fd_sc_hd__decap_3
X_4081_ net400 _1512_ net403 VGND VGND VPWR VPWR _1515_ sky130_fd_sc_hd__o21ai_1
XFILLER_95_377 VGND VGND VPWR VPWR sky130_fd_sc_hd__fill_1
X_3032_ net1071 net304 net211 VGND VGND VPWR VPWR _0538_ sky130_fd_sc_hd__mux2_1
XFILLER_48_271 VPWR VGND VPWR VGND sky130_ef_sc_hd__decap_12
XFILLER_55_219 VGND VGND VPWR VPWR sky130_fd_sc_hd__decap_4
XFILLER_91_561 VGND VGND VPWR VPWR sky130_fd_sc_hd__fill_1
XTAP_TAPCELL_ROW_34_601 VGND VPWR sky130_fd_sc_hd__tapvpwrvgnd_1
XFILLER_36_477 VGND VGND VPWR VPWR sky130_fd_sc_hd__decap_3
XTAP_TAPCELL_ROW_62_910 VGND VPWR sky130_fd_sc_hd__tapvpwrvgnd_1
X_4983_ clknet_leaf_19_clk _1038_ VGND VGND VPWR VPWR lsu.load_fifo.queue\[14\]\[4\]
+ sky130_fd_sc_hd__dfxtp_1
X_3934_ _1383_ _1382_ net360 VGND VGND VPWR VPWR _1384_ sky130_fd_sc_hd__mux2_1
X_3865_ net1255 _1325_ net253 VGND VGND VPWR VPWR _1022_ sky130_fd_sc_hd__mux2_1
X_2816_ net335 net1042 net228 VGND VGND VPWR VPWR _0329_ sky130_fd_sc_hd__mux2_1
XTAP_TAPCELL_ROW_14_380 VGND VPWR sky130_fd_sc_hd__tapvpwrvgnd_1
XPHY_EDGE_ROW_12_Left_119 VGND VGND VPWR VPWR sky130_fd_sc_hd__decap_3
X_3796_ lsu.load_fifo.queue\[4\]\[29\] lsu.load_fifo.queue\[5\]\[29\] lsu.load_fifo.queue\[6\]\[29\]
+ lsu.load_fifo.queue\[7\]\[29\] net394 net377 VGND VGND VPWR VPWR _1266_ sky130_fd_sc_hd__mux4_1
XFILLER_11_38 VGND VGND VPWR VPWR sky130_fd_sc_hd__fill_1
X_2747_ net506 net274 _2026_ VGND VGND VPWR VPWR _0267_ sky130_fd_sc_hd__mux2_1
X_2678_ net657 net344 net230 VGND VGND VPWR VPWR _0202_ sky130_fd_sc_hd__mux2_1
X_4417_ clknet_leaf_68_clk _0474_ VGND VGND VPWR VPWR lsu.load_fifo.queue\[5\]\[25\]
+ sky130_fd_sc_hd__dfxtp_1
Xfanout313 lsu.load_fifo.data_in\[21\] VGND VGND VPWR VPWR net313 sky130_fd_sc_hd__clkbuf_2
Xfanout302 net303 VGND VGND VPWR VPWR net302 sky130_fd_sc_hd__clkbuf_2
Xfanout335 lsu.load_fifo.data_in\[10\] VGND VGND VPWR VPWR net335 sky130_fd_sc_hd__buf_1
X_4348_ clknet_leaf_76_clk _0405_ VGND VGND VPWR VPWR lsu.load_fifo.queue\[7\]\[22\]
+ sky130_fd_sc_hd__dfxtp_1
Xfanout357 lsu.load_fifo.r_ptr\[3\] VGND VGND VPWR VPWR net357 sky130_fd_sc_hd__clkbuf_4
Xfanout324 lsu.load_fifo.data_in\[15\] VGND VGND VPWR VPWR net324 sky130_fd_sc_hd__clkbuf_2
Xfanout346 lsu.load_fifo.data_in\[4\] VGND VGND VPWR VPWR net346 sky130_fd_sc_hd__clkbuf_2
XFILLER_86_344 VPWR VGND VPWR VGND sky130_ef_sc_hd__decap_12
Xfanout379 net381 VGND VGND VPWR VPWR net379 sky130_fd_sc_hd__clkbuf_4
X_4279_ clknet_leaf_69_clk _0336_ VGND VGND VPWR VPWR lsu.load_fifo.queue\[9\]\[17\]
+ sky130_fd_sc_hd__dfxtp_1
XPHY_EDGE_ROW_21_Left_128 VGND VGND VPWR VPWR sky130_fd_sc_hd__decap_3
Xfanout368 net369 VGND VGND VPWR VPWR net368 sky130_fd_sc_hd__clkbuf_4
XFILLER_86_377 VPWR VGND VPWR VGND sky130_ef_sc_hd__decap_12
XFILLER_46_219 VPWR VGND VPWR VGND sky130_ef_sc_hd__decap_12
XFILLER_82_561 VGND VGND VPWR VPWR sky130_fd_sc_hd__fill_1
XFILLER_15_617 VPWR VGND VPWR VGND sky130_ef_sc_hd__decap_12
XFILLER_14_138 VGND VGND VPWR VPWR sky130_fd_sc_hd__fill_2
XPHY_EDGE_ROW_30_Left_137 VGND VGND VPWR VPWR sky130_fd_sc_hd__decap_3
XFILLER_52_89 VGND VGND VPWR VPWR sky130_fd_sc_hd__fill_1
XFILLER_10_355 VGND VGND VPWR VPWR sky130_fd_sc_hd__decap_8
XTAP_TAPCELL_ROW_75_1057 VGND VPWR sky130_fd_sc_hd__tapvpwrvgnd_1
XFILLER_2_587 VGND VGND VPWR VPWR sky130_fd_sc_hd__fill_1
XTAP_TAPCELL_ROW_48_759 VGND VPWR sky130_fd_sc_hd__tapvpwrvgnd_1
XFILLER_73_561 VGND VGND VPWR VPWR sky130_fd_sc_hd__decap_3
XTAP_TAPCELL_ROW_86_1175 VGND VPWR sky130_fd_sc_hd__tapvpwrvgnd_1
XFILLER_21_609 VGND VGND VPWR VPWR sky130_fd_sc_hd__decap_6
XFILLER_20_108 VGND VGND VPWR VPWR sky130_fd_sc_hd__fill_1
XFILLER_41_480 VGND VGND VPWR VPWR sky130_fd_sc_hd__fill_1
XTAP_TAPCELL_ROW_11_350 VGND VPWR sky130_fd_sc_hd__tapvpwrvgnd_1
X_3650_ _1130_ _1131_ VGND VGND VPWR VPWR _1132_ sky130_fd_sc_hd__nand2_1
Xrebuffer1 _1563_ VGND VGND VPWR VPWR net469 sky130_fd_sc_hd__buf_4
X_2601_ net38 net259 _1986_ _1987_ VGND VGND VPWR VPWR _1988_ sky130_fd_sc_hd__a22o_1
X_3581_ net423 VGND VGND VPWR VPWR _0145_ sky130_fd_sc_hd__inv_2
X_2532_ _1936_ VGND VGND VPWR VPWR _1937_ sky130_fd_sc_hd__inv_2
XTAP_TAPCELL_ROW_97_1293 VGND VPWR sky130_fd_sc_hd__tapvpwrvgnd_1
XFILLER_54_3 VGND VGND VPWR VPWR sky130_fd_sc_hd__fill_2
X_2463_ net81 net265 VGND VGND VPWR VPWR _1888_ sky130_fd_sc_hd__nand2_1
X_4202_ clknet_leaf_53_clk _0259_ VGND VGND VPWR VPWR lsu.store_fifo.queue\[6\]\[0\]
+ sky130_fd_sc_hd__dfxtp_1
X_2394_ _1796_ _1801_ _1808_ _1832_ VGND VGND VPWR VPWR _1833_ sky130_fd_sc_hd__and4_1
X_4133_ clknet_leaf_67_clk _0190_ VGND VGND VPWR VPWR lsu.store_fifo.queue\[10\]\[3\]
+ sky130_fd_sc_hd__dfxtp_1
X_4064_ net401 _1498_ VGND VGND VPWR VPWR _1499_ sky130_fd_sc_hd__nor2_1
XFILLER_49_591 VGND VGND VPWR VPWR sky130_fd_sc_hd__fill_1
X_3015_ net587 net339 net213 VGND VGND VPWR VPWR _0521_ sky130_fd_sc_hd__mux2_1
XFILLER_83_369 VGND VGND VPWR VPWR sky130_fd_sc_hd__fill_1
X_4966_ clknet_leaf_9_clk _1021_ _0152_ VGND VGND VPWR VPWR acc.byte2\[3\] sky130_fd_sc_hd__dfrtp_1
X_4897_ clknet_leaf_30_clk _0952_ VGND VGND VPWR VPWR lsu.load_fifo.queue\[12\]\[24\]
+ sky130_fd_sc_hd__dfxtp_1
X_3917_ net1273 _1369_ net254 VGND VGND VPWR VPWR _1014_ sky130_fd_sc_hd__mux2_1
X_3848_ lsu.load_fifo.queue\[0\]\[22\] lsu.load_fifo.queue\[1\]\[22\] lsu.load_fifo.queue\[2\]\[22\]
+ lsu.load_fifo.queue\[3\]\[22\] net389 net373 VGND VGND VPWR VPWR _1311_ sky130_fd_sc_hd__mux4_1
X_3779_ _1250_ _1249_ net362 VGND VGND VPWR VPWR _1251_ sky130_fd_sc_hd__mux2_1
XFILLER_3_329 VGND VGND VPWR VPWR sky130_fd_sc_hd__decap_6
XFILLER_105_268 VGND VGND VPWR VPWR sky130_fd_sc_hd__decap_4
XFILLER_101_430 VPWR VGND VPWR VGND sky130_ef_sc_hd__decap_12
Xfanout165 _1665_ VGND VGND VPWR VPWR net165 sky130_fd_sc_hd__buf_6
Xfanout187 _2044_ VGND VGND VPWR VPWR net187 sky130_fd_sc_hd__buf_4
Xfanout176 _2055_ VGND VGND VPWR VPWR net176 sky130_fd_sc_hd__buf_2
Xfanout198 _2057_ VGND VGND VPWR VPWR net198 sky130_fd_sc_hd__buf_4
XFILLER_103_51 VGND VGND VPWR VPWR sky130_fd_sc_hd__decap_4
XFILLER_74_369 VGND VGND VPWR VPWR sky130_fd_sc_hd__decap_4
XFILLER_55_561 VPWR VGND VPWR VGND sky130_ef_sc_hd__decap_12
XFILLER_15_425 VPWR VGND VPWR VGND sky130_ef_sc_hd__decap_12
XFILLER_27_296 VGND VGND VPWR VPWR sky130_fd_sc_hd__decap_8
XTAP_TAPCELL_ROW_45_729 VGND VPWR sky130_fd_sc_hd__tapvpwrvgnd_1
XFILLER_70_553 VGND VGND VPWR VPWR sky130_fd_sc_hd__decap_8
XFILLER_70_531 VGND VGND VPWR VPWR sky130_fd_sc_hd__fill_1
XFILLER_10_152 VGND VGND VPWR VPWR sky130_fd_sc_hd__decap_6
XFILLER_6_134 VGND VGND VPWR VPWR sky130_fd_sc_hd__decap_6
XFILLER_88_41 VPWR VGND VPWR VGND sky130_ef_sc_hd__decap_12
XFILLER_69_108 VGND VGND VPWR VPWR sky130_fd_sc_hd__decap_4
XFILLER_88_85 VPWR VGND VPWR VGND sky130_ef_sc_hd__decap_12
XFILLER_77_163 VGND VGND VPWR VPWR sky130_fd_sc_hd__decap_4
XFILLER_92_133 VGND VGND VPWR VPWR sky130_fd_sc_hd__decap_6
XFILLER_92_188 VGND VGND VPWR VPWR sky130_fd_sc_hd__decap_8
X_4820_ clknet_leaf_13_clk _0877_ VGND VGND VPWR VPWR lsu.load_fifo.data_in\[30\]
+ sky130_fd_sc_hd__dfxtp_1
XFILLER_61_575 VPWR VGND VPWR VGND sky130_ef_sc_hd__decap_12
X_4751_ clknet_leaf_44_clk _0808_ _0065_ VGND VGND VPWR VPWR lsu.current_store_addr\[19\]
+ sky130_fd_sc_hd__dfrtp_1
XTAP_TAPCELL_ROW_99_1322 VGND VPWR sky130_fd_sc_hd__tapvpwrvgnd_1
X_4682_ clknet_leaf_25_clk _0739_ _0028_ VGND VGND VPWR VPWR lsu.current_load_addr\[12\]
+ sky130_fd_sc_hd__dfrtp_1
X_3702_ _1182_ _1183_ VGND VGND VPWR VPWR _1184_ sky130_fd_sc_hd__nand2_1
X_3633_ lsu.loader_state\[1\] VGND VGND VPWR VPWR _1116_ sky130_fd_sc_hd__inv_2
X_3564_ net431 VGND VGND VPWR VPWR _0128_ sky130_fd_sc_hd__inv_2
X_2515_ lsu.current_load_addr\[3\] lsu.current_load_addr\[2\] lsu.current_load_addr\[1\]
+ lsu.current_load_addr\[0\] VGND VGND VPWR VPWR _1921_ sky130_fd_sc_hd__and4_1
X_3495_ net432 VGND VGND VPWR VPWR _0059_ sky130_fd_sc_hd__inv_2
X_2446_ lsu.current_store_addr\[13\] _1851_ lsu.current_store_addr\[14\] VGND VGND
+ VPWR VPWR _1875_ sky130_fd_sc_hd__a21oi_1
X_2377_ _1811_ _1814_ _1810_ VGND VGND VPWR VPWR _1816_ sky130_fd_sc_hd__o21ai_1
XFILLER_68_141 VGND VGND VPWR VPWR sky130_fd_sc_hd__decap_4
X_4116_ net1238 _1546_ net247 VGND VGND VPWR VPWR _0992_ sky130_fd_sc_hd__mux2_1
XFILLER_56_303 VGND VGND VPWR VPWR sky130_fd_sc_hd__decap_4
X_4047_ net271 _1483_ VGND VGND VPWR VPWR _1484_ sky130_fd_sc_hd__nor2_1
XFILLER_12_406 VPWR VGND VPWR VGND sky130_ef_sc_hd__decap_12
X_4949_ clknet_leaf_22_clk _1004_ _0135_ VGND VGND VPWR VPWR acc.byte0\[2\] sky130_fd_sc_hd__dfrtp_1
XTAP_TAPCELL_ROW_22_467 VGND VPWR sky130_fd_sc_hd__tapvpwrvgnd_1
XTAP_TAPCELL_ROW_50_776 VGND VPWR sky130_fd_sc_hd__tapvpwrvgnd_1
XPHY_EDGE_ROW_104_Left_211 VGND VGND VPWR VPWR sky130_fd_sc_hd__decap_3
XFILLER_106_533 VGND VGND VPWR VPWR sky130_fd_sc_hd__fill_2
XFILLER_106_511 VGND VGND VPWR VPWR sky130_fd_sc_hd__decap_3
XFILLER_79_439 VGND VGND VPWR VPWR sky130_fd_sc_hd__fill_1
XTAP_TAPCELL_ROW_72_1027 VGND VPWR sky130_fd_sc_hd__tapvpwrvgnd_1
XFILLER_58_11 VGND VGND VPWR VPWR sky130_fd_sc_hd__fill_1
XFILLER_87_461 VGND VGND VPWR VPWR sky130_fd_sc_hd__decap_8
XFILLER_47_303 VGND VGND VPWR VPWR sky130_fd_sc_hd__decap_3
XFILLER_74_21 VGND VGND VPWR VPWR sky130_fd_sc_hd__decap_6
XTAP_TAPCELL_ROW_58_865 VGND VPWR sky130_fd_sc_hd__tapvpwrvgnd_1
XTAP_TAPCELL_ROW_83_1145 VGND VPWR sky130_fd_sc_hd__tapvpwrvgnd_1
XFILLER_43_553 VGND VGND VPWR VPWR sky130_fd_sc_hd__decap_6
XFILLER_90_53 VPWR VGND VPWR VGND sky130_ef_sc_hd__decap_12
XFILLER_90_97 VPWR VGND VPWR VGND sky130_ef_sc_hd__decap_12
XFILLER_11_461 VPWR VGND VPWR VGND sky130_ef_sc_hd__decap_12
XTAP_TAPCELL_ROW_94_1263 VGND VPWR sky130_fd_sc_hd__tapvpwrvgnd_1
X_2300_ lsu.store_counter\[10\] net240 _1729_ lsu.store_counter\[11\] VGND VGND VPWR
+ VPWR _1754_ sky130_fd_sc_hd__a31o_1
X_3280_ net881 net278 _2053_ VGND VGND VPWR VPWR _0843_ sky130_fd_sc_hd__mux2_1
X_2231_ net479 net165 _1668_ net243 lsu.load_counter\[4\] VGND VGND VPWR VPWR _1704_
+ sky130_fd_sc_hd__o2111a_1
XFILLER_97_269 VGND VGND VPWR VPWR sky130_fd_sc_hd__decap_8
X_2162_ lsu.load_counter\[16\] _1576_ _1579_ _1575_ _1580_ VGND VGND VPWR VPWR _1652_
+ sky130_fd_sc_hd__a2111oi_4
XFILLER_38_336 VGND VGND VPWR VPWR sky130_fd_sc_hd__fill_2
X_2093_ _1566_ _1582_ VGND VGND VPWR VPWR _1583_ sky130_fd_sc_hd__and2_4
X_4803_ clknet_leaf_4_clk _0860_ VGND VGND VPWR VPWR lsu.load_fifo.data_in\[13\] sky130_fd_sc_hd__dfxtp_1
X_4734_ clknet_leaf_46_clk _0791_ _0048_ VGND VGND VPWR VPWR lsu.current_store_addr\[2\]
+ sky130_fd_sc_hd__dfrtp_1
X_2995_ net1130 net310 net190 VGND VGND VPWR VPWR _0503_ sky130_fd_sc_hd__mux2_1
X_4665_ clknet_leaf_59_clk _0722_ VGND VGND VPWR VPWR lsu.store_fifo.queue\[15\]\[5\]
+ sky130_fd_sc_hd__dfxtp_1
X_3616_ lsu.load_counter\[16\] VGND VGND VPWR VPWR _1099_ sky130_fd_sc_hd__inv_2
X_4596_ clknet_leaf_16_clk _0653_ VGND VGND VPWR VPWR lsu.load_fifo.queue\[8\]\[12\]
+ sky130_fd_sc_hd__dfxtp_1
X_3547_ net438 VGND VGND VPWR VPWR _0111_ sky130_fd_sc_hd__inv_2
XFILLER_88_225 VPWR VGND VPWR VGND sky130_ef_sc_hd__decap_12
XFILLER_103_558 VGND VGND VPWR VPWR sky130_fd_sc_hd__fill_2
X_3478_ net440 VGND VGND VPWR VPWR _0042_ sky130_fd_sc_hd__inv_2
X_2429_ net90 _1862_ _1718_ VGND VGND VPWR VPWR _1863_ sky130_fd_sc_hd__mux2_1
XFILLER_76_409 VGND VGND VPWR VPWR sky130_fd_sc_hd__decap_3
XFILLER_69_461 VPWR VGND VPWR VGND sky130_ef_sc_hd__decap_12
XFILLER_69_494 VGND VGND VPWR VPWR sky130_fd_sc_hd__decap_8
XFILLER_28_25 VGND VGND VPWR VPWR sky130_fd_sc_hd__decap_3
XTAP_TAPCELL_ROW_27_526 VGND VPWR sky130_fd_sc_hd__tapvpwrvgnd_1
XFILLER_44_306 VGND VGND VPWR VPWR sky130_fd_sc_hd__fill_2
XTAP_TAPCELL_ROW_55_835 VGND VPWR sky130_fd_sc_hd__tapvpwrvgnd_1
XFILLER_56_188 VGND VGND VPWR VPWR sky130_fd_sc_hd__decap_8
XFILLER_37_380 VGND VGND VPWR VPWR sky130_fd_sc_hd__decap_3
XFILLER_12_203 VGND VGND VPWR VPWR sky130_fd_sc_hd__fill_1
XFILLER_52_350 VGND VGND VPWR VPWR sky130_fd_sc_hd__decap_3
XFILLER_40_512 VGND VGND VPWR VPWR sky130_fd_sc_hd__decap_4
XFILLER_100_41 VPWR VGND VPWR VGND sky130_ef_sc_hd__decap_12
XFILLER_100_85 VPWR VGND VPWR VGND sky130_ef_sc_hd__decap_12
XFILLER_40_589 VGND VGND VPWR VPWR sky130_fd_sc_hd__decap_8
XFILLER_4_413 VGND VGND VPWR VPWR sky130_fd_sc_hd__decap_6
XFILLER_4_457 VPWR VGND VPWR VGND sky130_ef_sc_hd__decap_12
XFILLER_106_363 VGND VGND VPWR VPWR sky130_fd_sc_hd__fill_1
XFILLER_79_225 VGND VGND VPWR VPWR sky130_fd_sc_hd__decap_6
XFILLER_67_409 VGND VGND VPWR VPWR sky130_fd_sc_hd__fill_1
XFILLER_47_111 VGND VGND VPWR VPWR sky130_fd_sc_hd__fill_1
XFILLER_75_497 VGND VGND VPWR VPWR sky130_fd_sc_hd__decap_6
XFILLER_16_531 VGND VGND VPWR VPWR sky130_fd_sc_hd__fill_1
XFILLER_90_489 VPWR VGND VPWR VGND sky130_ef_sc_hd__decap_12
XFILLER_90_467 VGND VGND VPWR VPWR sky130_fd_sc_hd__decap_8
XFILLER_31_545 VGND VGND VPWR VPWR sky130_fd_sc_hd__fill_2
X_2780_ net276 net1092 _2030_ VGND VGND VPWR VPWR _0296_ sky130_fd_sc_hd__mux2_1
Xhold207 lsu.load_fifo.queue\[3\]\[16\] VGND VGND VPWR VPWR net675 sky130_fd_sc_hd__dlygate4sd3_1
X_4450_ clknet_leaf_7_clk _0507_ VGND VGND VPWR VPWR lsu.load_fifo.queue\[4\]\[26\]
+ sky130_fd_sc_hd__dfxtp_1
X_4381_ clknet_leaf_15_clk _0438_ VGND VGND VPWR VPWR lsu.load_fifo.queue\[6\]\[21\]
+ sky130_fd_sc_hd__dfxtp_1
X_3401_ net971 net320 net199 VGND VGND VPWR VPWR _1051_ sky130_fd_sc_hd__mux2_1
Xhold229 lsu.store_fifo.queue\[12\]\[7\] VGND VGND VPWR VPWR net697 sky130_fd_sc_hd__dlygate4sd3_1
Xhold218 lsu.store_fifo.queue\[12\]\[1\] VGND VGND VPWR VPWR net686 sky130_fd_sc_hd__dlygate4sd3_1
X_3332_ net592 net326 net173 VGND VGND VPWR VPWR _0942_ sky130_fd_sc_hd__mux2_1
XFILLER_98_589 VGND VGND VPWR VPWR sky130_fd_sc_hd__decap_8
X_3263_ lsu.current_store_addr\[12\] net1122 net258 VGND VGND VPWR VPWR _0823_ sky130_fd_sc_hd__mux2_1
X_2214_ _1101_ _1672_ VGND VGND VPWR VPWR _1694_ sky130_fd_sc_hd__and2_1
X_5002_ clknet_leaf_80_clk _1057_ VGND VGND VPWR VPWR lsu.load_fifo.queue\[14\]\[23\]
+ sky130_fd_sc_hd__dfxtp_1
X_3194_ net1003 net310 net203 VGND VGND VPWR VPWR _0695_ sky130_fd_sc_hd__mux2_1
X_2145_ net481 _1552_ VGND VGND VPWR VPWR _1635_ sky130_fd_sc_hd__xnor2_2
XFILLER_93_261 VPWR VGND VPWR VGND sky130_ef_sc_hd__decap_12
XFILLER_26_317 VGND VGND VPWR VPWR sky130_fd_sc_hd__decap_3
X_2076_ _1565_ net11 net12 VGND VGND VPWR VPWR _1566_ sky130_fd_sc_hd__or3_4
Xclkbuf_3_5__f_clk clknet_0_clk VGND VGND VPWR VPWR clknet_3_5__leaf_clk sky130_fd_sc_hd__clkbuf_16
XFILLER_53_158 VGND VGND VPWR VPWR sky130_fd_sc_hd__decap_8
XFILLER_53_169 VGND VGND VPWR VPWR sky130_fd_sc_hd__decap_8
XTAP_TAPCELL_ROW_52_805 VGND VPWR sky130_fd_sc_hd__tapvpwrvgnd_1
XFILLER_22_589 VPWR VGND VPWR VGND sky130_ef_sc_hd__decap_12
XTAP_TAPCELL_ROW_32_584 VGND VPWR sky130_fd_sc_hd__tapvpwrvgnd_1
X_2978_ net1021 net344 net191 VGND VGND VPWR VPWR _0486_ sky130_fd_sc_hd__mux2_1
XTAP_TAPCELL_ROW_60_893 VGND VPWR sky130_fd_sc_hd__tapvpwrvgnd_1
X_4717_ clknet_leaf_43_clk _0774_ VGND VGND VPWR VPWR net124 sky130_fd_sc_hd__dfxtp_1
X_4648_ clknet_leaf_51_clk _0705_ _0004_ VGND VGND VPWR VPWR lsu.store_fifo.w_ptr\[0\]
+ sky130_fd_sc_hd__dfrtp_4
Xhold730 lsu.load_fifo.queue\[12\]\[3\] VGND VGND VPWR VPWR net1198 sky130_fd_sc_hd__dlygate4sd3_1
X_4579_ clknet_leaf_81_clk _0636_ VGND VGND VPWR VPWR lsu.load_fifo.queue\[0\]\[27\]
+ sky130_fd_sc_hd__dfxtp_1
Xhold763 lsu.load_fifo.queue\[5\]\[25\] VGND VGND VPWR VPWR net1231 sky130_fd_sc_hd__dlygate4sd3_1
XFILLER_1_405 VPWR VGND VPWR VGND sky130_ef_sc_hd__decap_12
Xhold752 lsu.store_fifo.queue\[5\]\[7\] VGND VGND VPWR VPWR net1220 sky130_fd_sc_hd__dlygate4sd3_1
Xhold741 _0816_ VGND VGND VPWR VPWR net1209 sky130_fd_sc_hd__dlygate4sd3_1
XFILLER_1_449 VPWR VGND VPWR VGND sky130_ef_sc_hd__decap_12
Xhold785 lsu.load_fifo.data_in\[19\] VGND VGND VPWR VPWR net1253 sky130_fd_sc_hd__dlygate4sd3_1
Xhold774 net151 VGND VGND VPWR VPWR net1242 sky130_fd_sc_hd__dlygate4sd3_1
Xhold796 acc.byte1\[3\] VGND VGND VPWR VPWR net1264 sky130_fd_sc_hd__dlygate4sd3_1
XFILLER_39_57 VGND VGND VPWR VPWR sky130_fd_sc_hd__fill_1
XFILLER_49_409 VGND VGND VPWR VPWR sky130_fd_sc_hd__fill_1
XTAP_TAPCELL_ROW_68_982 VGND VPWR sky130_fd_sc_hd__tapvpwrvgnd_1
XTAP_TAPCELL_ROW_4_276 VGND VPWR sky130_fd_sc_hd__tapvpwrvgnd_1
XFILLER_72_445 VPWR VGND VPWR VGND sky130_ef_sc_hd__decap_12
XFILLER_72_489 VPWR VGND VPWR VGND sky130_ef_sc_hd__decap_12
XFILLER_32_309 VPWR VGND VPWR VGND sky130_ef_sc_hd__decap_12
XTAP_TAPCELL_ROW_80_1115 VGND VPWR sky130_fd_sc_hd__tapvpwrvgnd_1
XFILLER_9_505 VPWR VGND VPWR VGND sky130_ef_sc_hd__decap_12
XTAP_TAPCELL_ROW_78_1088 VGND VPWR sky130_fd_sc_hd__tapvpwrvgnd_1
XTAP_TAPCELL_ROW_91_1233 VGND VPWR sky130_fd_sc_hd__tapvpwrvgnd_1
XFILLER_96_41 VPWR VGND VPWR VGND sky130_ef_sc_hd__decap_12
XFILLER_96_85 VPWR VGND VPWR VGND sky130_ef_sc_hd__decap_12
XFILLER_95_537 VGND VGND VPWR VPWR sky130_fd_sc_hd__fill_2
Xhold90 lsu.load_fifo.queue\[15\]\[6\] VGND VGND VPWR VPWR net558 sky130_fd_sc_hd__dlygate4sd3_1
XFILLER_35_103 VGND VGND VPWR VPWR sky130_fd_sc_hd__decap_8
XFILLER_90_253 VPWR VGND VPWR VGND sky130_ef_sc_hd__decap_12
X_3950_ lsu.load_fifo.queue\[0\]\[7\] lsu.load_fifo.queue\[1\]\[7\] lsu.load_fifo.queue\[2\]\[7\]
+ lsu.load_fifo.queue\[3\]\[7\] net396 net379 VGND VGND VPWR VPWR _1398_ sky130_fd_sc_hd__mux4_1
X_2901_ net556 net296 net195 VGND VGND VPWR VPWR _0412_ sky130_fd_sc_hd__mux2_1
XFILLER_16_383 VPWR VGND VPWR VGND sky130_ef_sc_hd__decap_12
X_3881_ lsu.load_fifo.queue\[8\]\[17\] lsu.load_fifo.queue\[9\]\[17\] lsu.load_fifo.queue\[10\]\[17\]
+ lsu.load_fifo.queue\[11\]\[17\] net388 net371 VGND VGND VPWR VPWR _1339_ sky130_fd_sc_hd__mux4_1
XFILLER_84_3 VGND VGND VPWR VPWR sky130_fd_sc_hd__decap_3
X_2832_ net302 net1172 net228 VGND VGND VPWR VPWR _0345_ sky130_fd_sc_hd__mux2_1
X_2763_ net771 net286 _2028_ VGND VGND VPWR VPWR _0281_ sky130_fd_sc_hd__mux2_1
X_4502_ clknet_leaf_3_clk _0559_ VGND VGND VPWR VPWR lsu.load_fifo.queue\[2\]\[14\]
+ sky130_fd_sc_hd__dfxtp_1
X_2694_ net1041 net313 net232 VGND VGND VPWR VPWR _0218_ sky130_fd_sc_hd__mux2_1
XFILLER_6_94 VGND VGND VPWR VPWR sky130_fd_sc_hd__decap_8
X_4433_ clknet_leaf_82_clk _0490_ VGND VGND VPWR VPWR lsu.load_fifo.queue\[4\]\[9\]
+ sky130_fd_sc_hd__dfxtp_1
X_4364_ clknet_leaf_5_clk _0421_ VGND VGND VPWR VPWR lsu.load_fifo.queue\[6\]\[4\]
+ sky130_fd_sc_hd__dfxtp_1
X_4295_ clknet_leaf_78_clk _0352_ VGND VGND VPWR VPWR lsu.load_fifo.queue\[10\]\[1\]
+ sky130_fd_sc_hd__dfxtp_1
X_3315_ net294 net70 net251 VGND VGND VPWR VPWR _0877_ sky130_fd_sc_hd__mux2_1
X_3246_ net799 lsu.current_load_addr\[18\] net237 VGND VGND VPWR VPWR _0784_ sky130_fd_sc_hd__mux2_1
X_3177_ net603 net344 net202 VGND VGND VPWR VPWR _0678_ sky130_fd_sc_hd__mux2_1
X_2128_ net20 net19 net18 net471 VGND VGND VPWR VPWR _1618_ sky130_fd_sc_hd__or4_1
XFILLER_81_220 VGND VGND VPWR VPWR sky130_fd_sc_hd__decap_4
XTAP_TAPCELL_ROW_1_246 VGND VPWR sky130_fd_sc_hd__tapvpwrvgnd_1
XFILLER_26_136 VGND VGND VPWR VPWR sky130_fd_sc_hd__decap_4
XTAP_TAPCELL_ROW_37_632 VGND VPWR sky130_fd_sc_hd__tapvpwrvgnd_1
XTAP_TAPCELL_ROW_65_941 VGND VPWR sky130_fd_sc_hd__tapvpwrvgnd_1
XFILLER_41_25 VGND VGND VPWR VPWR sky130_fd_sc_hd__fill_2
XFILLER_41_47 VGND VGND VPWR VPWR sky130_fd_sc_hd__fill_1
XTAP_TAPCELL_ROW_9_324 VGND VPWR sky130_fd_sc_hd__tapvpwrvgnd_1
Xhold560 lsu.load_fifo.queue\[13\]\[6\] VGND VGND VPWR VPWR net1028 sky130_fd_sc_hd__dlygate4sd3_1
Xhold571 lsu.store_fifo.queue\[3\]\[4\] VGND VGND VPWR VPWR net1039 sky130_fd_sc_hd__dlygate4sd3_1
Xhold582 lsu.load_fifo.queue\[2\]\[15\] VGND VGND VPWR VPWR net1050 sky130_fd_sc_hd__dlygate4sd3_1
Xhold593 lsu.store_fifo.queue\[13\]\[4\] VGND VGND VPWR VPWR net1061 sky130_fd_sc_hd__dlygate4sd3_1
XFILLER_89_386 VGND VGND VPWR VPWR sky130_fd_sc_hd__fill_2
XFILLER_1_279 VGND VGND VPWR VPWR sky130_fd_sc_hd__fill_1
XFILLER_66_77 VGND VGND VPWR VPWR sky130_fd_sc_hd__decap_6
XFILLER_45_423 VGND VGND VPWR VPWR sky130_fd_sc_hd__decap_6
XFILLER_45_478 VGND VGND VPWR VPWR sky130_fd_sc_hd__decap_3
XFILLER_13_386 VGND VGND VPWR VPWR sky130_fd_sc_hd__decap_6
XFILLER_5_541 VPWR VGND VPWR VGND sky130_ef_sc_hd__decap_12
Xoutput109 net109 VGND VGND VPWR VPWR load_addr[14] sky130_fd_sc_hd__buf_2
XFILLER_5_585 VPWR VGND VPWR VGND sky130_ef_sc_hd__decap_12
X_3100_ net300 net1205 net186 VGND VGND VPWR VPWR _0604_ sky130_fd_sc_hd__mux2_1
X_4080_ net270 _1513_ VGND VGND VPWR VPWR _1514_ sky130_fd_sc_hd__nor2_1
X_3031_ net683 net306 net213 VGND VGND VPWR VPWR _0537_ sky130_fd_sc_hd__mux2_1
X_4982_ clknet_leaf_87_clk _1037_ VGND VGND VPWR VPWR lsu.load_fifo.queue\[14\]\[3\]
+ sky130_fd_sc_hd__dfxtp_1
XFILLER_24_629 VGND VGND VPWR VPWR sky130_fd_sc_hd__fill_1
XTAP_TAPCELL_ROW_34_602 VGND VPWR sky130_fd_sc_hd__tapvpwrvgnd_1
XTAP_TAPCELL_ROW_62_911 VGND VPWR sky130_fd_sc_hd__tapvpwrvgnd_1
X_3933_ lsu.load_fifo.queue\[0\]\[9\] lsu.load_fifo.queue\[1\]\[9\] lsu.load_fifo.queue\[2\]\[9\]
+ lsu.load_fifo.queue\[3\]\[9\] net387 net370 VGND VGND VPWR VPWR _1383_ sky130_fd_sc_hd__mux4_1
X_3864_ _1321_ _1324_ net356 VGND VGND VPWR VPWR _1325_ sky130_fd_sc_hd__mux2_1
XTAP_TAPCELL_ROW_14_381 VGND VPWR sky130_fd_sc_hd__tapvpwrvgnd_1
X_2815_ net337 net1017 net226 VGND VGND VPWR VPWR _0328_ sky130_fd_sc_hd__mux2_1
XTAP_TAPCELL_ROW_42_690 VGND VPWR sky130_fd_sc_hd__tapvpwrvgnd_1
X_3795_ net1304 _1265_ net256 VGND VGND VPWR VPWR _1032_ sky130_fd_sc_hd__mux2_1
X_2746_ net1022 net277 _2026_ VGND VGND VPWR VPWR _0266_ sky130_fd_sc_hd__mux2_1
X_2677_ net590 net346 net232 VGND VGND VPWR VPWR _0201_ sky130_fd_sc_hd__mux2_1
X_4416_ clknet_leaf_30_clk _0473_ VGND VGND VPWR VPWR lsu.load_fifo.queue\[5\]\[24\]
+ sky130_fd_sc_hd__dfxtp_1
Xfanout314 lsu.load_fifo.data_in\[20\] VGND VGND VPWR VPWR net314 sky130_fd_sc_hd__clkbuf_2
Xfanout303 lsu.load_fifo.data_in\[26\] VGND VGND VPWR VPWR net303 sky130_fd_sc_hd__dlymetal6s2s_1
X_4347_ clknet_leaf_15_clk _0404_ VGND VGND VPWR VPWR lsu.load_fifo.queue\[7\]\[21\]
+ sky130_fd_sc_hd__dfxtp_1
Xfanout336 lsu.load_fifo.data_in\[9\] VGND VGND VPWR VPWR net336 sky130_fd_sc_hd__clkbuf_2
Xfanout325 lsu.load_fifo.data_in\[15\] VGND VGND VPWR VPWR net325 sky130_fd_sc_hd__buf_1
Xfanout347 lsu.load_fifo.data_in\[4\] VGND VGND VPWR VPWR net347 sky130_fd_sc_hd__dlymetal6s2s_1
XFILLER_86_356 VGND VGND VPWR VPWR sky130_fd_sc_hd__decap_8
X_4278_ clknet_leaf_30_clk _0335_ VGND VGND VPWR VPWR lsu.load_fifo.queue\[9\]\[16\]
+ sky130_fd_sc_hd__dfxtp_1
Xfanout369 net382 VGND VGND VPWR VPWR net369 sky130_fd_sc_hd__clkbuf_2
Xfanout358 lsu.load_fifo.r_ptr\[3\] VGND VGND VPWR VPWR net358 sky130_fd_sc_hd__buf_4
X_3229_ net867 lsu.current_load_addr\[1\] net237 VGND VGND VPWR VPWR _0767_ sky130_fd_sc_hd__mux2_1
XFILLER_86_389 VGND VGND VPWR VPWR sky130_fd_sc_hd__decap_3
XFILLER_54_253 VGND VGND VPWR VPWR sky130_fd_sc_hd__decap_6
XFILLER_15_629 VGND VGND VPWR VPWR sky130_fd_sc_hd__fill_1
XFILLER_6_305 VGND VGND VPWR VPWR sky130_fd_sc_hd__decap_3
XFILLER_6_349 VGND VGND VPWR VPWR sky130_fd_sc_hd__decap_6
XTAP_TAPCELL_ROW_75_1058 VGND VPWR sky130_fd_sc_hd__tapvpwrvgnd_1
XFILLER_2_533 VPWR VGND VPWR VGND sky130_ef_sc_hd__decap_12
XFILLER_96_109 VPWR VGND VPWR VGND sky130_ef_sc_hd__decap_12
Xhold390 lsu.load_fifo.queue\[7\]\[11\] VGND VGND VPWR VPWR net858 sky130_fd_sc_hd__dlygate4sd3_1
XFILLER_92_326 VPWR VGND VPWR VGND sky130_ef_sc_hd__decap_12
XFILLER_45_220 VGND VGND VPWR VPWR sky130_fd_sc_hd__decap_4
XFILLER_45_231 VGND VGND VPWR VPWR sky130_fd_sc_hd__fill_1
XTAP_TAPCELL_ROW_86_1176 VGND VPWR sky130_fd_sc_hd__tapvpwrvgnd_1
XFILLER_73_584 VPWR VGND VPWR VGND sky130_ef_sc_hd__decap_12
XFILLER_45_286 VGND VGND VPWR VPWR sky130_fd_sc_hd__decap_4
X_2600_ net261 _1920_ VGND VGND VPWR VPWR _1987_ sky130_fd_sc_hd__nor2_1
XTAP_TAPCELL_ROW_11_351 VGND VPWR sky130_fd_sc_hd__tapvpwrvgnd_1
X_3580_ net422 VGND VGND VPWR VPWR _0144_ sky130_fd_sc_hd__inv_2
X_2531_ lsu.current_load_addr\[19\] _1931_ net262 VGND VGND VPWR VPWR _1936_ sky130_fd_sc_hd__a21oi_1
XTAP_TAPCELL_ROW_97_1294 VGND VPWR sky130_fd_sc_hd__tapvpwrvgnd_1
XFILLER_87_109 VGND VGND VPWR VPWR sky130_fd_sc_hd__decap_3
XFILLER_5_393 VPWR VGND VPWR VGND sky130_ef_sc_hd__decap_12
X_4201_ clknet_leaf_71_clk _0258_ VGND VGND VPWR VPWR lsu.store_fifo.queue\[7\]\[9\]
+ sky130_fd_sc_hd__dfxtp_1
X_2462_ net252 _1886_ VGND VGND VPWR VPWR _1887_ sky130_fd_sc_hd__nor2_1
X_2393_ lsu.store_counter\[0\] net2 _1809_ _1810_ _1815_ VGND VGND VPWR VPWR _1832_
+ sky130_fd_sc_hd__o2111a_1
XFILLER_3_51 VGND VGND VPWR VPWR sky130_fd_sc_hd__decap_4
X_4132_ clknet_leaf_60_clk _0189_ VGND VGND VPWR VPWR lsu.store_fifo.queue\[10\]\[2\]
+ sky130_fd_sc_hd__dfxtp_1
X_4063_ lsu.store_fifo.queue\[0\]\[4\] lsu.store_fifo.queue\[1\]\[4\] lsu.store_fifo.queue\[2\]\[4\]
+ lsu.store_fifo.queue\[3\]\[4\] net415 net409 VGND VGND VPWR VPWR _1498_ sky130_fd_sc_hd__mux4_1
XFILLER_56_507 VGND VGND VPWR VPWR sky130_fd_sc_hd__decap_4
X_3014_ net688 net341 net213 VGND VGND VPWR VPWR _0520_ sky130_fd_sc_hd__mux2_1
XTAP_TAPCELL_ROW_19_440 VGND VPWR sky130_fd_sc_hd__tapvpwrvgnd_1
XFILLER_36_242 VGND VGND VPWR VPWR sky130_fd_sc_hd__decap_8
XFILLER_36_253 VGND VGND VPWR VPWR sky130_fd_sc_hd__decap_3
X_4965_ clknet_leaf_8_clk _1020_ _0151_ VGND VGND VPWR VPWR acc.byte2\[2\] sky130_fd_sc_hd__dfrtp_1
X_3916_ _1366_ _1368_ _1365_ _1367_ net358 net364 VGND VGND VPWR VPWR _1369_ sky130_fd_sc_hd__mux4_1
X_4896_ clknet_leaf_80_clk _0951_ VGND VGND VPWR VPWR lsu.load_fifo.queue\[12\]\[23\]
+ sky130_fd_sc_hd__dfxtp_1
X_3847_ lsu.load_fifo.queue\[4\]\[22\] lsu.load_fifo.queue\[5\]\[22\] lsu.load_fifo.queue\[6\]\[22\]
+ lsu.load_fifo.queue\[7\]\[22\] net390 net373 VGND VGND VPWR VPWR _1310_ sky130_fd_sc_hd__mux4_1
X_3778_ lsu.load_fifo.queue\[0\]\[31\] lsu.load_fifo.queue\[1\]\[31\] lsu.load_fifo.queue\[2\]\[31\]
+ lsu.load_fifo.queue\[3\]\[31\] net389 net372 VGND VGND VPWR VPWR _1250_ sky130_fd_sc_hd__mux4_1
X_2729_ net288 net1226 net234 VGND VGND VPWR VPWR _0250_ sky130_fd_sc_hd__mux2_1
XFILLER_105_225 VGND VGND VPWR VPWR sky130_fd_sc_hd__decap_4
XFILLER_105_247 VGND VGND VPWR VPWR sky130_fd_sc_hd__decap_4
XFILLER_101_442 VGND VGND VPWR VPWR sky130_fd_sc_hd__decap_6
XFILLER_59_345 VGND VGND VPWR VPWR sky130_fd_sc_hd__fill_1
Xfanout166 net168 VGND VGND VPWR VPWR net166 sky130_fd_sc_hd__buf_8
Xfanout188 _2044_ VGND VGND VPWR VPWR net188 sky130_fd_sc_hd__buf_2
Xfanout199 _2057_ VGND VGND VPWR VPWR net199 sky130_fd_sc_hd__clkbuf_4
Xfanout177 _2046_ VGND VGND VPWR VPWR net177 sky130_fd_sc_hd__buf_4
XFILLER_86_197 VPWR VGND VPWR VGND sky130_ef_sc_hd__decap_12
XPHY_EDGE_ROW_29_Right_29 VGND VGND VPWR VPWR sky130_fd_sc_hd__decap_3
XFILLER_47_57 VGND VGND VPWR VPWR sky130_fd_sc_hd__decap_4
XFILLER_55_573 VGND VGND VPWR VPWR sky130_fd_sc_hd__decap_4
XFILLER_15_437 VGND VGND VPWR VPWR sky130_fd_sc_hd__decap_8
XFILLER_42_256 VPWR VGND VPWR VGND sky130_ef_sc_hd__decap_12
XFILLER_8_29 VGND VGND VPWR VPWR sky130_fd_sc_hd__decap_4
XPHY_EDGE_ROW_38_Right_38 VGND VGND VPWR VPWR sky130_fd_sc_hd__decap_3
XFILLER_6_124 VGND VGND VPWR VPWR sky130_fd_sc_hd__fill_2
XFILLER_6_102 VGND VGND VPWR VPWR sky130_fd_sc_hd__fill_2
XFILLER_88_53 VPWR VGND VPWR VGND sky130_ef_sc_hd__decap_12
XFILLER_88_97 VPWR VGND VPWR VGND sky130_ef_sc_hd__decap_12
XFILLER_2_363 VGND VGND VPWR VPWR sky130_fd_sc_hd__fill_1
XPHY_EDGE_ROW_47_Right_47 VGND VGND VPWR VPWR sky130_fd_sc_hd__decap_3
XTAP_TAPCELL_ROW_16_410 VGND VPWR sky130_fd_sc_hd__tapvpwrvgnd_1
XFILLER_33_223 VGND VGND VPWR VPWR sky130_fd_sc_hd__fill_1
XFILLER_61_587 VGND VGND VPWR VPWR sky130_fd_sc_hd__decap_8
X_4750_ clknet_leaf_44_clk _0807_ _0064_ VGND VGND VPWR VPWR lsu.current_store_addr\[18\]
+ sky130_fd_sc_hd__dfrtp_1
XPHY_EDGE_ROW_56_Right_56 VGND VGND VPWR VPWR sky130_fd_sc_hd__decap_3
X_4681_ clknet_leaf_25_clk _0738_ _0027_ VGND VGND VPWR VPWR lsu.current_load_addr\[11\]
+ sky130_fd_sc_hd__dfrtp_1
XTAP_TAPCELL_ROW_99_1323 VGND VPWR sky130_fd_sc_hd__tapvpwrvgnd_1
X_3701_ acc.byte3\[4\] acc.byte2\[4\] VGND VGND VPWR VPWR _1183_ sky130_fd_sc_hd__or2_1
X_3632_ lsu.store_fifo.w_ptr\[2\] VGND VGND VPWR VPWR _1115_ sky130_fd_sc_hd__inv_2
X_3563_ net433 VGND VGND VPWR VPWR _0127_ sky130_fd_sc_hd__inv_2
X_2514_ lsu.current_load_addr\[2\] lsu.current_load_addr\[1\] lsu.current_load_addr\[0\]
+ VGND VGND VPWR VPWR _1920_ sky130_fd_sc_hd__and3_1
X_3494_ net441 VGND VGND VPWR VPWR _0058_ sky130_fd_sc_hd__inv_2
XFILLER_5_190 VGND VGND VPWR VPWR sky130_fd_sc_hd__fill_1
XFILLER_88_429 VGND VGND VPWR VPWR sky130_fd_sc_hd__decap_3
X_2445_ net1297 net252 _1873_ _1874_ VGND VGND VPWR VPWR _0804_ sky130_fd_sc_hd__a22o_1
XPHY_EDGE_ROW_65_Right_65 VGND VGND VPWR VPWR sky130_fd_sc_hd__decap_3
X_2376_ _1811_ _1812_ _1813_ VGND VGND VPWR VPWR _1815_ sky130_fd_sc_hd__nor3_1
X_4115_ net404 _1543_ _1545_ _1540_ _1541_ VGND VGND VPWR VPWR _1546_ sky130_fd_sc_hd__a32o_1
X_4046_ lsu.store_fifo.queue\[12\]\[6\] lsu.store_fifo.queue\[13\]\[6\] lsu.store_fifo.queue\[14\]\[6\]
+ lsu.store_fifo.queue\[15\]\[6\] net414 net410 VGND VGND VPWR VPWR _1483_ sky130_fd_sc_hd__mux4_1
XFILLER_17_49 VGND VGND VPWR VPWR sky130_fd_sc_hd__decap_6
XFILLER_64_381 VGND VGND VPWR VPWR sky130_fd_sc_hd__fill_1
XPHY_EDGE_ROW_74_Right_74 VGND VGND VPWR VPWR sky130_fd_sc_hd__decap_3
XFILLER_12_418 VGND VGND VPWR VPWR sky130_fd_sc_hd__fill_2
XFILLER_52_587 VGND VGND VPWR VPWR sky130_fd_sc_hd__fill_1
X_4948_ clknet_leaf_10_clk _1003_ _0134_ VGND VGND VPWR VPWR acc.byte0\[1\] sky130_fd_sc_hd__dfrtp_1
X_4879_ clknet_leaf_1_clk _0934_ VGND VGND VPWR VPWR lsu.load_fifo.queue\[12\]\[6\]
+ sky130_fd_sc_hd__dfxtp_1
XTAP_TAPCELL_ROW_22_468 VGND VPWR sky130_fd_sc_hd__tapvpwrvgnd_1
XTAP_TAPCELL_ROW_50_777 VGND VPWR sky130_fd_sc_hd__tapvpwrvgnd_1
XPHY_EDGE_ROW_83_Right_83 VGND VGND VPWR VPWR sky130_fd_sc_hd__decap_3
XTAP_TAPCELL_ROW_72_1017 VGND VPWR sky130_fd_sc_hd__tapvpwrvgnd_1
XFILLER_59_186 VGND VGND VPWR VPWR sky130_fd_sc_hd__fill_1
XTAP_TAPCELL_ROW_58_866 VGND VPWR sky130_fd_sc_hd__tapvpwrvgnd_1
XFILLER_62_307 VGND VGND VPWR VPWR sky130_fd_sc_hd__fill_1
XPHY_EDGE_ROW_92_Right_92 VGND VGND VPWR VPWR sky130_fd_sc_hd__decap_3
XFILLER_43_521 VGND VGND VPWR VPWR sky130_fd_sc_hd__decap_8
XTAP_TAPCELL_ROW_83_1146 VGND VPWR sky130_fd_sc_hd__tapvpwrvgnd_1
XFILLER_43_565 VGND VGND VPWR VPWR sky130_fd_sc_hd__fill_1
XFILLER_70_384 VGND VGND VPWR VPWR sky130_fd_sc_hd__decap_6
XFILLER_43_598 VGND VGND VPWR VPWR sky130_fd_sc_hd__fill_2
XFILLER_90_65 VPWR VGND VPWR VGND sky130_ef_sc_hd__decap_12
XFILLER_11_473 VPWR VGND VPWR VGND sky130_ef_sc_hd__decap_12
XFILLER_99_30 VPWR VGND VPWR VGND sky130_ef_sc_hd__decap_12
XTAP_TAPCELL_ROW_94_1264 VGND VPWR sky130_fd_sc_hd__tapvpwrvgnd_1
X_2230_ _1104_ _1702_ _1703_ net160 VGND VGND VPWR VPWR _0911_ sky130_fd_sc_hd__a2bb2o_4
X_2161_ _1599_ _1615_ _1645_ _1650_ VGND VGND VPWR VPWR _1651_ sky130_fd_sc_hd__o31a_1
X_2092_ net11 _1565_ net12 VGND VGND VPWR VPWR _1582_ sky130_fd_sc_hd__o21ai_1
XFILLER_0_41 VPWR VGND VPWR VGND sky130_ef_sc_hd__decap_12
XFILLER_34_510 VGND VGND VPWR VPWR sky130_fd_sc_hd__decap_6
XFILLER_65_167 VGND VGND VPWR VPWR sky130_fd_sc_hd__fill_1
XFILLER_0_85 VGND VGND VPWR VPWR sky130_fd_sc_hd__decap_8
XFILLER_61_351 VGND VGND VPWR VPWR sky130_fd_sc_hd__decap_4
XTAP_TAPCELL_ROW_103_1360 VGND VPWR sky130_fd_sc_hd__tapvpwrvgnd_1
XPHY_EDGE_ROW_100_Right_100 VGND VGND VPWR VPWR sky130_fd_sc_hd__decap_3
X_2994_ net1013 net312 net191 VGND VGND VPWR VPWR _0502_ sky130_fd_sc_hd__mux2_1
X_4802_ clknet_leaf_20_clk _0859_ VGND VGND VPWR VPWR lsu.load_fifo.data_in\[12\]
+ sky130_fd_sc_hd__dfxtp_1
X_4733_ clknet_leaf_46_clk _0790_ _0047_ VGND VGND VPWR VPWR lsu.current_store_addr\[1\]
+ sky130_fd_sc_hd__dfrtp_1
X_4664_ clknet_leaf_61_clk _0721_ VGND VGND VPWR VPWR lsu.store_fifo.queue\[15\]\[4\]
+ sky130_fd_sc_hd__dfxtp_1
X_3615_ lsu.load_counter\[18\] VGND VGND VPWR VPWR _1098_ sky130_fd_sc_hd__inv_2
X_4595_ clknet_leaf_84_clk _0652_ VGND VGND VPWR VPWR lsu.load_fifo.queue\[8\]\[11\]
+ sky130_fd_sc_hd__dfxtp_1
X_3546_ net438 VGND VGND VPWR VPWR _0110_ sky130_fd_sc_hd__inv_2
XFILLER_1_609 VGND VGND VPWR VPWR sky130_fd_sc_hd__decap_6
XFILLER_88_237 VPWR VGND VPWR VGND sky130_ef_sc_hd__decap_12
X_3477_ net425 VGND VGND VPWR VPWR _0041_ sky130_fd_sc_hd__inv_2
X_2428_ lsu.current_store_addr\[19\] _1855_ VGND VGND VPWR VPWR _1862_ sky130_fd_sc_hd__xor2_1
X_2359_ lsu.store_counter\[10\] _1606_ _1609_ lsu.store_counter\[9\] VGND VGND VPWR
+ VPWR _1798_ sky130_fd_sc_hd__a22o_1
XFILLER_28_59 VGND VGND VPWR VPWR sky130_fd_sc_hd__decap_6
XFILLER_56_145 VGND VGND VPWR VPWR sky130_fd_sc_hd__fill_2
X_4029_ net1240 net247 _1467_ VGND VGND VPWR VPWR _1000_ sky130_fd_sc_hd__o21a_1
XTAP_TAPCELL_ROW_27_527 VGND VPWR sky130_fd_sc_hd__tapvpwrvgnd_1
XTAP_TAPCELL_ROW_55_836 VGND VPWR sky130_fd_sc_hd__tapvpwrvgnd_1
XFILLER_52_362 VGND VGND VPWR VPWR sky130_fd_sc_hd__fill_2
XFILLER_100_53 VPWR VGND VPWR VGND sky130_ef_sc_hd__decap_12
XFILLER_40_557 VGND VGND VPWR VPWR sky130_fd_sc_hd__decap_4
XFILLER_100_97 VPWR VGND VPWR VGND sky130_ef_sc_hd__decap_12
XFILLER_60_46 VGND VGND VPWR VPWR sky130_fd_sc_hd__fill_1
XFILLER_20_270 VGND VGND VPWR VPWR sky130_fd_sc_hd__decap_6
XFILLER_106_342 VGND VGND VPWR VPWR sky130_fd_sc_hd__decap_4
XFILLER_4_469 VGND VGND VPWR VPWR sky130_fd_sc_hd__decap_6
XFILLER_106_386 VGND VGND VPWR VPWR sky130_fd_sc_hd__fill_2
XFILLER_87_281 VGND VGND VPWR VPWR sky130_fd_sc_hd__fill_2
XFILLER_28_381 VGND VGND VPWR VPWR sky130_fd_sc_hd__fill_1
XFILLER_16_587 VGND VGND VPWR VPWR sky130_fd_sc_hd__fill_1
XFILLER_7_263 VPWR VGND VPWR VGND sky130_ef_sc_hd__decap_12
Xhold208 lsu.load_fifo.queue\[7\]\[19\] VGND VGND VPWR VPWR net676 sky130_fd_sc_hd__dlygate4sd3_1
X_3400_ net908 net323 net201 VGND VGND VPWR VPWR _1050_ sky130_fd_sc_hd__mux2_1
Xhold219 lsu.load_fifo.queue\[6\]\[20\] VGND VGND VPWR VPWR net687 sky130_fd_sc_hd__dlygate4sd3_1
X_4380_ clknet_leaf_85_clk _0437_ VGND VGND VPWR VPWR lsu.load_fifo.queue\[6\]\[20\]
+ sky130_fd_sc_hd__dfxtp_1
X_3331_ net742 net328 net173 VGND VGND VPWR VPWR _0941_ sky130_fd_sc_hd__mux2_1
X_3262_ lsu.current_store_addr\[11\] net775 net258 VGND VGND VPWR VPWR _0822_ sky130_fd_sc_hd__mux2_1
X_2213_ net167 net164 _1672_ net263 net244 VGND VGND VPWR VPWR _1693_ sky130_fd_sc_hd__o221a_1
X_3193_ net1115 net312 net204 VGND VGND VPWR VPWR _0694_ sky130_fd_sc_hd__mux2_1
X_5001_ clknet_leaf_75_clk _1056_ VGND VGND VPWR VPWR lsu.load_fifo.queue\[14\]\[22\]
+ sky130_fd_sc_hd__dfxtp_1
X_2144_ lsu.load_counter\[3\] net474 _1632_ VGND VGND VPWR VPWR _1634_ sky130_fd_sc_hd__and3_1
XFILLER_93_273 VGND VGND VPWR VPWR sky130_fd_sc_hd__decap_6
XFILLER_26_307 VGND VGND VPWR VPWR sky130_fd_sc_hd__fill_1
X_2075_ _1563_ net9 net8 net10 VGND VGND VPWR VPWR _1565_ sky130_fd_sc_hd__or4_4
XTAP_TAPCELL_ROW_52_806 VGND VPWR sky130_fd_sc_hd__tapvpwrvgnd_1
X_2977_ net677 net346 net191 VGND VGND VPWR VPWR _0485_ sky130_fd_sc_hd__mux2_1
X_4716_ clknet_leaf_43_clk _0773_ VGND VGND VPWR VPWR net123 sky130_fd_sc_hd__dfxtp_1
XTAP_TAPCELL_ROW_32_585 VGND VPWR sky130_fd_sc_hd__tapvpwrvgnd_1
XTAP_TAPCELL_ROW_60_894 VGND VPWR sky130_fd_sc_hd__tapvpwrvgnd_1
X_4647_ clknet_leaf_75_clk _0704_ VGND VGND VPWR VPWR lsu.load_fifo.queue\[15\]\[31\]
+ sky130_fd_sc_hd__dfxtp_1
Xhold720 lsu.load_fifo.queue\[5\]\[15\] VGND VGND VPWR VPWR net1188 sky130_fd_sc_hd__dlygate4sd3_1
XFILLER_89_502 VGND VGND VPWR VPWR sky130_fd_sc_hd__fill_2
Xhold742 lsu.load_fifo.queue\[9\]\[3\] VGND VGND VPWR VPWR net1210 sky130_fd_sc_hd__dlygate4sd3_1
Xhold753 lsu.load_fifo.queue\[1\]\[3\] VGND VGND VPWR VPWR net1221 sky130_fd_sc_hd__dlygate4sd3_1
XFILLER_1_417 VPWR VGND VPWR VGND sky130_ef_sc_hd__decap_12
Xhold764 lsu.load_fifo.queue\[13\]\[22\] VGND VGND VPWR VPWR net1232 sky130_fd_sc_hd__dlygate4sd3_1
Xhold731 lsu.store_fifo.queue\[7\]\[4\] VGND VGND VPWR VPWR net1199 sky130_fd_sc_hd__dlygate4sd3_1
X_4578_ clknet_leaf_10_clk _0635_ VGND VGND VPWR VPWR lsu.load_fifo.queue\[0\]\[26\]
+ sky130_fd_sc_hd__dfxtp_1
XFILLER_103_334 VGND VGND VPWR VPWR sky130_fd_sc_hd__fill_2
XFILLER_103_301 VGND VGND VPWR VPWR sky130_fd_sc_hd__fill_2
X_3529_ net441 VGND VGND VPWR VPWR _0093_ sky130_fd_sc_hd__inv_2
Xhold797 acc.byte2\[5\] VGND VGND VPWR VPWR net1265 sky130_fd_sc_hd__dlygate4sd3_1
Xhold786 acc.byte1\[7\] VGND VGND VPWR VPWR net1254 sky130_fd_sc_hd__dlygate4sd3_1
Xhold775 net153 VGND VGND VPWR VPWR net1243 sky130_fd_sc_hd__dlygate4sd3_1
XFILLER_84_251 VGND VGND VPWR VPWR sky130_fd_sc_hd__fill_1
XTAP_TAPCELL_ROW_68_983 VGND VPWR sky130_fd_sc_hd__tapvpwrvgnd_1
XTAP_TAPCELL_ROW_4_277 VGND VPWR sky130_fd_sc_hd__tapvpwrvgnd_1
XFILLER_29_178 VGND VGND VPWR VPWR sky130_fd_sc_hd__fill_1
XFILLER_55_35 VGND VGND VPWR VPWR sky130_fd_sc_hd__decap_8
XFILLER_44_137 VGND VGND VPWR VPWR sky130_fd_sc_hd__decap_3
XFILLER_55_57 VGND VGND VPWR VPWR sky130_fd_sc_hd__decap_4
XFILLER_72_457 VPWR VGND VPWR VGND sky130_ef_sc_hd__decap_12
XFILLER_44_159 VPWR VGND VPWR VGND sky130_ef_sc_hd__decap_12
XTAP_TAPCELL_ROW_80_1105 VGND VPWR sky130_fd_sc_hd__tapvpwrvgnd_1
XFILLER_9_517 VPWR VGND VPWR VGND sky130_ef_sc_hd__decap_12
XFILLER_40_365 VGND VGND VPWR VPWR sky130_fd_sc_hd__fill_2
XTAP_TAPCELL_ROW_78_1089 VGND VPWR sky130_fd_sc_hd__tapvpwrvgnd_1
XTAP_TAPCELL_ROW_91_1234 VGND VPWR sky130_fd_sc_hd__tapvpwrvgnd_1
XFILLER_96_53 VPWR VGND VPWR VGND sky130_ef_sc_hd__decap_12
XFILLER_95_516 VGND VGND VPWR VPWR sky130_fd_sc_hd__fill_1
XFILLER_0_461 VPWR VGND VPWR VGND sky130_ef_sc_hd__decap_12
XFILLER_96_97 VPWR VGND VPWR VGND sky130_ef_sc_hd__decap_12
Xhold91 lsu.load_fifo.queue\[2\]\[29\] VGND VGND VPWR VPWR net559 sky130_fd_sc_hd__dlygate4sd3_1
Xhold80 lsu.load_fifo.queue\[4\]\[29\] VGND VGND VPWR VPWR net548 sky130_fd_sc_hd__dlygate4sd3_1
XFILLER_63_402 VGND VGND VPWR VPWR sky130_fd_sc_hd__fill_1
XFILLER_90_265 VPWR VGND VPWR VGND sky130_ef_sc_hd__decap_12
XFILLER_16_351 VGND VGND VPWR VPWR sky130_fd_sc_hd__fill_1
XFILLER_51_608 VGND VGND VPWR VPWR sky130_fd_sc_hd__fill_2
X_2900_ net812 net298 net195 VGND VGND VPWR VPWR _0411_ sky130_fd_sc_hd__mux2_1
XFILLER_16_395 VPWR VGND VPWR VGND sky130_ef_sc_hd__decap_12
X_3880_ lsu.load_fifo.queue\[12\]\[17\] lsu.load_fifo.queue\[13\]\[17\] lsu.load_fifo.queue\[14\]\[17\]
+ lsu.load_fifo.queue\[15\]\[17\] net388 net371 VGND VGND VPWR VPWR _1338_ sky130_fd_sc_hd__mux4_1
Xclkbuf_leaf_70_clk clknet_3_4__leaf_clk VGND VGND VPWR VPWR clknet_leaf_70_clk sky130_fd_sc_hd__clkbuf_8
XTAP_TAPCELL_ROW_100_1330 VGND VPWR sky130_fd_sc_hd__tapvpwrvgnd_1
X_2831_ net304 net1114 net227 VGND VGND VPWR VPWR _0344_ sky130_fd_sc_hd__mux2_1
XFILLER_77_3 VGND VGND VPWR VPWR sky130_fd_sc_hd__decap_4
X_2762_ net529 net288 _2028_ VGND VGND VPWR VPWR _0280_ sky130_fd_sc_hd__mux2_1
X_4501_ clknet_leaf_4_clk _0558_ VGND VGND VPWR VPWR lsu.load_fifo.queue\[2\]\[13\]
+ sky130_fd_sc_hd__dfxtp_1
X_2693_ net863 net315 net230 VGND VGND VPWR VPWR _0217_ sky130_fd_sc_hd__mux2_1
X_4432_ clknet_leaf_55_clk _0489_ VGND VGND VPWR VPWR lsu.load_fifo.queue\[4\]\[8\]
+ sky130_fd_sc_hd__dfxtp_1
XFILLER_98_321 VPWR VGND VPWR VGND sky130_ef_sc_hd__decap_12
X_4363_ clknet_leaf_87_clk _0420_ VGND VGND VPWR VPWR lsu.load_fifo.queue\[6\]\[3\]
+ sky130_fd_sc_hd__dfxtp_1
X_3314_ net297 net68 net250 VGND VGND VPWR VPWR _0876_ sky130_fd_sc_hd__mux2_1
X_4294_ clknet_leaf_35_clk _0351_ VGND VGND VPWR VPWR lsu.load_fifo.queue\[10\]\[0\]
+ sky130_fd_sc_hd__dfxtp_1
X_3245_ net565 lsu.current_load_addr\[17\] net237 VGND VGND VPWR VPWR _0783_ sky130_fd_sc_hd__mux2_1
XFILLER_27_605 VGND VGND VPWR VPWR sky130_fd_sc_hd__decap_3
X_3176_ net601 net346 net204 VGND VGND VPWR VPWR _0677_ sky130_fd_sc_hd__mux2_1
X_2127_ net19 net18 net471 VGND VGND VPWR VPWR _1617_ sky130_fd_sc_hd__or3_1
XFILLER_94_593 VGND VGND VPWR VPWR sky130_fd_sc_hd__fill_1
XTAP_TAPCELL_ROW_1_236 VGND VPWR sky130_fd_sc_hd__tapvpwrvgnd_1
XTAP_TAPCELL_ROW_37_633 VGND VPWR sky130_fd_sc_hd__tapvpwrvgnd_1
XTAP_TAPCELL_ROW_65_942 VGND VPWR sky130_fd_sc_hd__tapvpwrvgnd_1
XFILLER_81_298 VGND VGND VPWR VPWR sky130_fd_sc_hd__fill_1
XFILLER_41_107 VGND VGND VPWR VPWR sky130_fd_sc_hd__decap_4
Xclkbuf_leaf_61_clk clknet_3_5__leaf_clk VGND VGND VPWR VPWR clknet_leaf_61_clk sky130_fd_sc_hd__clkbuf_8
XFILLER_22_365 VGND VGND VPWR VPWR sky130_fd_sc_hd__fill_2
XTAP_TAPCELL_ROW_9_325 VGND VPWR sky130_fd_sc_hd__tapvpwrvgnd_1
XFILLER_1_225 VPWR VGND VPWR VGND sky130_ef_sc_hd__decap_12
Xhold561 lsu.load_fifo.queue\[1\]\[1\] VGND VGND VPWR VPWR net1029 sky130_fd_sc_hd__dlygate4sd3_1
Xhold572 lsu.load_fifo.queue\[5\]\[26\] VGND VGND VPWR VPWR net1040 sky130_fd_sc_hd__dlygate4sd3_1
Xhold550 lsu.load_fifo.queue\[7\]\[4\] VGND VGND VPWR VPWR net1018 sky130_fd_sc_hd__dlygate4sd3_1
XFILLER_1_258 VGND VGND VPWR VPWR sky130_fd_sc_hd__fill_1
Xhold583 lsu.load_fifo.queue\[5\]\[31\] VGND VGND VPWR VPWR net1051 sky130_fd_sc_hd__dlygate4sd3_1
Xhold594 lsu.load_fifo.queue\[6\]\[19\] VGND VGND VPWR VPWR net1062 sky130_fd_sc_hd__dlygate4sd3_1
XFILLER_106_41 VPWR VGND VPWR VGND sky130_ef_sc_hd__decap_12
Xclkbuf_leaf_52_clk clknet_3_6__leaf_clk VGND VGND VPWR VPWR clknet_leaf_52_clk sky130_fd_sc_hd__clkbuf_8
XFILLER_40_195 VGND VGND VPWR VPWR sky130_fd_sc_hd__fill_1
XFILLER_31_70 VGND VGND VPWR VPWR sky130_fd_sc_hd__fill_2
XFILLER_5_553 VGND VGND VPWR VPWR sky130_fd_sc_hd__decap_6
XFILLER_5_597 VPWR VGND VPWR VGND sky130_ef_sc_hd__decap_12
XFILLER_95_335 VGND VGND VPWR VPWR sky130_fd_sc_hd__fill_1
X_3030_ net595 net308 net211 VGND VGND VPWR VPWR _0536_ sky130_fd_sc_hd__mux2_1
XFILLER_76_593 VGND VGND VPWR VPWR sky130_fd_sc_hd__fill_1
X_4981_ clknet_leaf_20_clk _1036_ VGND VGND VPWR VPWR lsu.load_fifo.queue\[14\]\[2\]
+ sky130_fd_sc_hd__dfxtp_1
XTAP_TAPCELL_ROW_34_603 VGND VPWR sky130_fd_sc_hd__tapvpwrvgnd_1
XFILLER_51_427 VGND VGND VPWR VPWR sky130_fd_sc_hd__fill_1
XTAP_TAPCELL_ROW_62_912 VGND VPWR sky130_fd_sc_hd__tapvpwrvgnd_1
Xclkbuf_leaf_43_clk clknet_3_7__leaf_clk VGND VGND VPWR VPWR clknet_leaf_43_clk sky130_fd_sc_hd__clkbuf_8
X_3932_ lsu.load_fifo.queue\[4\]\[9\] lsu.load_fifo.queue\[5\]\[9\] lsu.load_fifo.queue\[6\]\[9\]
+ lsu.load_fifo.queue\[7\]\[9\] net387 net370 VGND VGND VPWR VPWR _1382_ sky130_fd_sc_hd__mux4_1
X_3863_ _1323_ _1322_ net360 VGND VGND VPWR VPWR _1324_ sky130_fd_sc_hd__mux2_1
XTAP_TAPCELL_ROW_14_382 VGND VPWR sky130_fd_sc_hd__tapvpwrvgnd_1
XTAP_TAPCELL_ROW_42_691 VGND VPWR sky130_fd_sc_hd__tapvpwrvgnd_1
X_2814_ net339 net801 net228 VGND VGND VPWR VPWR _0327_ sky130_fd_sc_hd__mux2_1
X_3794_ _1262_ _1264_ _1261_ _1263_ net358 net363 VGND VGND VPWR VPWR _1265_ sky130_fd_sc_hd__mux4_1
XFILLER_11_18 VGND VGND VPWR VPWR sky130_fd_sc_hd__decap_8
X_2745_ net608 net279 _2026_ VGND VGND VPWR VPWR _0265_ sky130_fd_sc_hd__mux2_1
X_2676_ net659 net348 net230 VGND VGND VPWR VPWR _0200_ sky130_fd_sc_hd__mux2_1
X_4415_ clknet_leaf_81_clk _0472_ VGND VGND VPWR VPWR lsu.load_fifo.queue\[5\]\[23\]
+ sky130_fd_sc_hd__dfxtp_1
Xfanout304 net305 VGND VGND VPWR VPWR net304 sky130_fd_sc_hd__clkbuf_2
X_4346_ clknet_leaf_85_clk _0403_ VGND VGND VPWR VPWR lsu.load_fifo.queue\[7\]\[20\]
+ sky130_fd_sc_hd__dfxtp_1
XFILLER_101_602 VPWR VGND VPWR VGND sky130_ef_sc_hd__decap_12
XFILLER_98_173 VGND VGND VPWR VPWR sky130_fd_sc_hd__decap_3
Xfanout337 lsu.load_fifo.data_in\[9\] VGND VGND VPWR VPWR net337 sky130_fd_sc_hd__buf_1
Xfanout315 lsu.load_fifo.data_in\[20\] VGND VGND VPWR VPWR net315 sky130_fd_sc_hd__buf_1
Xfanout348 lsu.load_fifo.data_in\[3\] VGND VGND VPWR VPWR net348 sky130_fd_sc_hd__clkbuf_2
Xfanout326 lsu.load_fifo.data_in\[14\] VGND VGND VPWR VPWR net326 sky130_fd_sc_hd__clkbuf_2
XFILLER_59_505 VGND VGND VPWR VPWR sky130_fd_sc_hd__fill_2
X_4277_ clknet_leaf_11_clk _0334_ VGND VGND VPWR VPWR lsu.load_fifo.queue\[9\]\[15\]
+ sky130_fd_sc_hd__dfxtp_1
Xfanout359 lsu.load_fifo.r_ptr\[3\] VGND VGND VPWR VPWR net359 sky130_fd_sc_hd__clkbuf_4
X_3228_ net623 lsu.current_load_addr\[0\] net237 VGND VGND VPWR VPWR _0766_ sky130_fd_sc_hd__mux2_1
X_3159_ net670 net315 net177 VGND VGND VPWR VPWR _0661_ sky130_fd_sc_hd__mux2_1
XFILLER_54_243 VGND VGND VPWR VPWR sky130_fd_sc_hd__decap_8
XFILLER_82_585 VGND VGND VPWR VPWR sky130_fd_sc_hd__decap_3
Xclkbuf_leaf_34_clk clknet_3_6__leaf_clk VGND VGND VPWR VPWR clknet_leaf_34_clk sky130_fd_sc_hd__clkbuf_8
XFILLER_10_379 VGND VGND VPWR VPWR sky130_fd_sc_hd__decap_3
XTAP_TAPCELL_ROW_75_1059 VGND VPWR sky130_fd_sc_hd__tapvpwrvgnd_1
XFILLER_2_501 VPWR VGND VPWR VGND sky130_ef_sc_hd__decap_12
Xhold380 lsu.load_fifo.queue\[10\]\[25\] VGND VGND VPWR VPWR net848 sky130_fd_sc_hd__dlygate4sd3_1
XFILLER_7_3 VPWR VGND VPWR VGND sky130_ef_sc_hd__decap_12
XFILLER_2_545 VPWR VGND VPWR VGND sky130_ef_sc_hd__decap_12
XFILLER_2_589 VPWR VGND VPWR VGND sky130_ef_sc_hd__decap_12
Xhold391 lsu.load_fifo.queue\[6\]\[30\] VGND VGND VPWR VPWR net859 sky130_fd_sc_hd__dlygate4sd3_1
XFILLER_92_338 VPWR VGND VPWR VGND sky130_ef_sc_hd__decap_12
XFILLER_18_435 VGND VGND VPWR VPWR sky130_fd_sc_hd__decap_4
XFILLER_45_254 VGND VGND VPWR VPWR sky130_fd_sc_hd__fill_1
XTAP_TAPCELL_ROW_86_1177 VGND VPWR sky130_fd_sc_hd__tapvpwrvgnd_1
XFILLER_73_596 VGND VGND VPWR VPWR sky130_fd_sc_hd__fill_2
Xclkbuf_leaf_25_clk clknet_3_2__leaf_clk VGND VGND VPWR VPWR clknet_leaf_25_clk sky130_fd_sc_hd__clkbuf_8
Xrebuffer3 net475 VGND VGND VPWR VPWR net471 sky130_fd_sc_hd__dlygate4sd1_1
XTAP_TAPCELL_ROW_11_352 VGND VPWR sky130_fd_sc_hd__tapvpwrvgnd_1
X_2530_ net36 net262 VGND VGND VPWR VPWR _1935_ sky130_fd_sc_hd__nand2_1
XFILLER_61_6 VGND VGND VPWR VPWR sky130_fd_sc_hd__fill_1
XTAP_TAPCELL_ROW_97_1295 VGND VPWR sky130_fd_sc_hd__tapvpwrvgnd_1
X_2461_ lsu.current_store_addr\[9\] _1847_ net265 VGND VGND VPWR VPWR _1886_ sky130_fd_sc_hd__a21oi_1
X_4200_ clknet_leaf_56_clk _0257_ VGND VGND VPWR VPWR lsu.store_fifo.queue\[7\]\[8\]
+ sky130_fd_sc_hd__dfxtp_1
X_2392_ _1780_ _1830_ _1829_ _1781_ VGND VGND VPWR VPWR _1831_ sky130_fd_sc_hd__a2bb2o_1
X_4131_ clknet_leaf_65_clk _0188_ VGND VGND VPWR VPWR lsu.store_fifo.queue\[10\]\[1\]
+ sky130_fd_sc_hd__dfxtp_1
X_4062_ net1244 net246 _1497_ VGND VGND VPWR VPWR _0997_ sky130_fd_sc_hd__o21a_1
XFILLER_83_316 VPWR VGND VPWR VGND sky130_ef_sc_hd__decap_12
X_3013_ net1007 net343 net210 VGND VGND VPWR VPWR _0519_ sky130_fd_sc_hd__mux2_1
XTAP_TAPCELL_ROW_19_441 VGND VPWR sky130_fd_sc_hd__tapvpwrvgnd_1
XTAP_TAPCELL_ROW_47_750 VGND VPWR sky130_fd_sc_hd__tapvpwrvgnd_1
XFILLER_36_265 VGND VGND VPWR VPWR sky130_fd_sc_hd__decap_4
X_4964_ clknet_leaf_72_clk _1019_ _0150_ VGND VGND VPWR VPWR acc.byte2\[1\] sky130_fd_sc_hd__dfrtp_1
Xclkbuf_leaf_16_clk clknet_3_2__leaf_clk VGND VGND VPWR VPWR clknet_leaf_16_clk sky130_fd_sc_hd__clkbuf_8
XTAP_TAPCELL_ROW_106_1391 VGND VPWR sky130_fd_sc_hd__tapvpwrvgnd_1
XFILLER_51_279 VGND VGND VPWR VPWR sky130_fd_sc_hd__fill_1
X_3915_ lsu.load_fifo.queue\[8\]\[12\] lsu.load_fifo.queue\[9\]\[12\] lsu.load_fifo.queue\[10\]\[12\]
+ lsu.load_fifo.queue\[11\]\[12\] net393 net376 VGND VGND VPWR VPWR _1368_ sky130_fd_sc_hd__mux4_1
X_4895_ clknet_leaf_72_clk _0950_ VGND VGND VPWR VPWR lsu.load_fifo.queue\[12\]\[22\]
+ sky130_fd_sc_hd__dfxtp_1
X_3846_ _1307_ _1308_ net361 VGND VGND VPWR VPWR _1309_ sky130_fd_sc_hd__mux2_1
X_3777_ lsu.load_fifo.queue\[4\]\[31\] lsu.load_fifo.queue\[5\]\[31\] lsu.load_fifo.queue\[6\]\[31\]
+ lsu.load_fifo.queue\[7\]\[31\] net387 net370 VGND VGND VPWR VPWR _1249_ sky130_fd_sc_hd__mux4_1
X_2728_ net290 net730 net234 VGND VGND VPWR VPWR _0249_ sky130_fd_sc_hd__mux2_1
XFILLER_105_259 VGND VGND VPWR VPWR sky130_fd_sc_hd__fill_1
XFILLER_105_237 VGND VGND VPWR VPWR sky130_fd_sc_hd__fill_1
X_2659_ net273 net1101 _2019_ VGND VGND VPWR VPWR _0186_ sky130_fd_sc_hd__mux2_1
XFILLER_87_611 VGND VGND VPWR VPWR sky130_fd_sc_hd__fill_1
X_4329_ clknet_leaf_87_clk _0386_ VGND VGND VPWR VPWR lsu.load_fifo.queue\[7\]\[3\]
+ sky130_fd_sc_hd__dfxtp_1
Xfanout167 net168 VGND VGND VPWR VPWR net167 sky130_fd_sc_hd__buf_4
Xfanout189 _2040_ VGND VGND VPWR VPWR net189 sky130_fd_sc_hd__buf_4
Xfanout178 _2046_ VGND VGND VPWR VPWR net178 sky130_fd_sc_hd__clkbuf_4
XFILLER_15_449 VPWR VGND VPWR VGND sky130_ef_sc_hd__decap_12
XFILLER_42_235 VGND VGND VPWR VPWR sky130_fd_sc_hd__decap_8
XFILLER_63_57 VGND VGND VPWR VPWR sky130_fd_sc_hd__fill_1
XFILLER_30_419 VGND VGND VPWR VPWR sky130_fd_sc_hd__fill_1
XFILLER_42_268 VGND VGND VPWR VPWR sky130_fd_sc_hd__decap_6
XFILLER_7_615 VGND VGND VPWR VPWR sky130_fd_sc_hd__fill_1
XFILLER_88_65 VGND VGND VPWR VPWR sky130_fd_sc_hd__decap_6
XFILLER_46_585 VGND VGND VPWR VPWR sky130_fd_sc_hd__decap_3
XFILLER_73_393 VGND VGND VPWR VPWR sky130_fd_sc_hd__decap_4
XTAP_TAPCELL_ROW_16_411 VGND VPWR sky130_fd_sc_hd__tapvpwrvgnd_1
XFILLER_18_287 VGND VGND VPWR VPWR sky130_fd_sc_hd__decap_3
XFILLER_33_279 VGND VGND VPWR VPWR sky130_fd_sc_hd__fill_1
X_3700_ acc.byte3\[4\] acc.byte2\[4\] VGND VGND VPWR VPWR _1182_ sky130_fd_sc_hd__nand2_1
XTAP_TAPCELL_ROW_99_1324 VGND VPWR sky130_fd_sc_hd__tapvpwrvgnd_1
X_4680_ clknet_leaf_28_clk _0737_ _0026_ VGND VGND VPWR VPWR lsu.current_load_addr\[10\]
+ sky130_fd_sc_hd__dfrtp_2
X_3631_ net402 VGND VGND VPWR VPWR _1114_ sky130_fd_sc_hd__inv_2
X_3562_ net431 VGND VGND VPWR VPWR _0126_ sky130_fd_sc_hd__inv_2
X_2513_ net37 net264 VGND VGND VPWR VPWR _1919_ sky130_fd_sc_hd__nor2_1
X_3493_ net433 VGND VGND VPWR VPWR _0057_ sky130_fd_sc_hd__inv_2
XFILLER_88_419 VGND VGND VPWR VPWR sky130_fd_sc_hd__fill_1
X_2444_ net86 net269 net238 VGND VGND VPWR VPWR _1874_ sky130_fd_sc_hd__o21a_1
Xclkbuf_leaf_5_clk clknet_3_0__leaf_clk VGND VGND VPWR VPWR clknet_leaf_5_clk sky130_fd_sc_hd__clkbuf_8
X_2375_ _1812_ _1813_ VGND VGND VPWR VPWR _1814_ sky130_fd_sc_hd__and2b_1
X_4114_ _1114_ _1544_ VGND VGND VPWR VPWR _1545_ sky130_fd_sc_hd__or2_1
Xclone8 _1666_ VGND VGND VPWR VPWR net476 sky130_fd_sc_hd__buf_8
X_4045_ lsu.store_fifo.queue\[4\]\[6\] lsu.store_fifo.queue\[5\]\[6\] lsu.store_fifo.queue\[6\]\[6\]
+ lsu.store_fifo.queue\[7\]\[6\] net415 net409 VGND VGND VPWR VPWR _1482_ sky130_fd_sc_hd__mux4_1
XFILLER_52_522 VGND VGND VPWR VPWR sky130_fd_sc_hd__decap_4
X_4947_ clknet_leaf_34_clk _1002_ _0133_ VGND VGND VPWR VPWR acc.byte0\[0\] sky130_fd_sc_hd__dfrtp_1
X_4878_ clknet_leaf_5_clk _0933_ VGND VGND VPWR VPWR lsu.load_fifo.queue\[12\]\[5\]
+ sky130_fd_sc_hd__dfxtp_1
XTAP_TAPCELL_ROW_22_469 VGND VPWR sky130_fd_sc_hd__tapvpwrvgnd_1
X_3829_ net1271 _1294_ net255 VGND VGND VPWR VPWR _1027_ sky130_fd_sc_hd__mux2_1
XTAP_TAPCELL_ROW_50_778 VGND VPWR sky130_fd_sc_hd__tapvpwrvgnd_1
XFILLER_106_524 VGND VGND VPWR VPWR sky130_fd_sc_hd__decap_4
XFILLER_3_117 VGND VGND VPWR VPWR sky130_fd_sc_hd__fill_1
XPHY_EDGE_ROW_18_Left_125 VGND VGND VPWR VPWR sky130_fd_sc_hd__decap_3
XTAP_TAPCELL_ROW_72_1018 VGND VPWR sky130_fd_sc_hd__tapvpwrvgnd_1
XTAP_TAPCELL_ROW_58_867 VGND VPWR sky130_fd_sc_hd__tapvpwrvgnd_1
XFILLER_90_628 VGND VGND VPWR VPWR sky130_fd_sc_hd__fill_2
XFILLER_74_45 VGND VGND VPWR VPWR sky130_fd_sc_hd__decap_4
XPHY_EDGE_ROW_27_Left_134 VGND VGND VPWR VPWR sky130_fd_sc_hd__decap_3
XFILLER_62_319 VGND VGND VPWR VPWR sky130_fd_sc_hd__decap_6
XFILLER_43_533 VGND VGND VPWR VPWR sky130_fd_sc_hd__decap_3
XFILLER_55_393 VGND VGND VPWR VPWR sky130_fd_sc_hd__decap_6
XTAP_TAPCELL_ROW_83_1147 VGND VPWR sky130_fd_sc_hd__tapvpwrvgnd_1
XFILLER_90_77 VGND VGND VPWR VPWR sky130_fd_sc_hd__decap_6
XFILLER_11_441 VGND VGND VPWR VPWR sky130_fd_sc_hd__decap_6
XFILLER_7_401 VPWR VGND VPWR VGND sky130_ef_sc_hd__decap_12
XFILLER_11_485 VPWR VGND VPWR VGND sky130_ef_sc_hd__decap_12
XFILLER_7_445 VGND VGND VPWR VPWR sky130_fd_sc_hd__decap_3
XPHY_EDGE_ROW_36_Left_143 VGND VGND VPWR VPWR sky130_fd_sc_hd__decap_3
XFILLER_99_42 VPWR VGND VPWR VGND sky130_ef_sc_hd__decap_12
XTAP_TAPCELL_ROW_94_1265 VGND VPWR sky130_fd_sc_hd__tapvpwrvgnd_1
XFILLER_97_205 VPWR VGND VPWR VGND sky130_ef_sc_hd__decap_12
XFILLER_78_452 VPWR VGND VPWR VGND sky130_ef_sc_hd__decap_12
X_2160_ _1603_ _1649_ _1590_ _1596_ _1598_ VGND VGND VPWR VPWR _1650_ sky130_fd_sc_hd__a2111o_1
XFILLER_65_113 VGND VGND VPWR VPWR sky130_fd_sc_hd__decap_4
X_2091_ _1580_ _1575_ _1579_ VGND VGND VPWR VPWR _1581_ sky130_fd_sc_hd__or3b_1
XFILLER_93_455 VGND VGND VPWR VPWR sky130_fd_sc_hd__fill_1
XPHY_EDGE_ROW_45_Left_152 VGND VGND VPWR VPWR sky130_fd_sc_hd__decap_3
XFILLER_0_53 VGND VGND VPWR VPWR sky130_fd_sc_hd__decap_3
XFILLER_0_97 VPWR VGND VPWR VGND sky130_ef_sc_hd__decap_12
XTAP_TAPCELL_ROW_103_1361 VGND VPWR sky130_fd_sc_hd__tapvpwrvgnd_1
X_4801_ clknet_leaf_86_clk _0858_ VGND VGND VPWR VPWR lsu.load_fifo.data_in\[11\]
+ sky130_fd_sc_hd__dfxtp_1
X_2993_ net696 net314 net189 VGND VGND VPWR VPWR _0501_ sky130_fd_sc_hd__mux2_1
X_4732_ clknet_leaf_46_clk _0789_ _0046_ VGND VGND VPWR VPWR lsu.current_store_addr\[0\]
+ sky130_fd_sc_hd__dfrtp_1
X_4663_ clknet_leaf_60_clk _0720_ VGND VGND VPWR VPWR lsu.store_fifo.queue\[15\]\[3\]
+ sky130_fd_sc_hd__dfxtp_1
XPHY_EDGE_ROW_54_Left_161 VGND VGND VPWR VPWR sky130_fd_sc_hd__decap_3
X_3614_ lsu.load_counter\[20\] VGND VGND VPWR VPWR _1097_ sky130_fd_sc_hd__inv_2
X_4594_ clknet_leaf_23_clk _0651_ VGND VGND VPWR VPWR lsu.load_fifo.queue\[8\]\[10\]
+ sky130_fd_sc_hd__dfxtp_1
X_3545_ net438 VGND VGND VPWR VPWR _0109_ sky130_fd_sc_hd__inv_2
XFILLER_103_505 VGND VGND VPWR VPWR sky130_fd_sc_hd__decap_4
XFILLER_0_109 VGND VGND VPWR VPWR sky130_fd_sc_hd__decap_3
X_3476_ net424 VGND VGND VPWR VPWR _0040_ sky130_fd_sc_hd__inv_2
X_2427_ net1299 _1861_ net242 VGND VGND VPWR VPWR _0809_ sky130_fd_sc_hd__mux2_1
XFILLER_88_249 VGND VGND VPWR VPWR sky130_fd_sc_hd__decap_3
X_2358_ lsu.store_counter\[11\] _1601_ _1606_ lsu.store_counter\[10\] VGND VGND VPWR
+ VPWR _1797_ sky130_fd_sc_hd__o22ai_1
XPHY_EDGE_ROW_63_Left_170 VGND VGND VPWR VPWR sky130_fd_sc_hd__decap_3
X_2289_ _1747_ _1746_ lsu.store_counter\[16\] VGND VGND VPWR VPWR _0896_ sky130_fd_sc_hd__mux2_1
XFILLER_71_105 VGND VGND VPWR VPWR sky130_fd_sc_hd__fill_1
X_4028_ net247 _1466_ VGND VGND VPWR VPWR _1467_ sky130_fd_sc_hd__nand2_1
XTAP_TAPCELL_ROW_27_528 VGND VPWR sky130_fd_sc_hd__tapvpwrvgnd_1
XFILLER_37_371 VGND VGND VPWR VPWR sky130_fd_sc_hd__decap_3
XFILLER_37_393 VGND VGND VPWR VPWR sky130_fd_sc_hd__fill_2
XTAP_TAPCELL_ROW_55_837 VGND VPWR sky130_fd_sc_hd__tapvpwrvgnd_1
XFILLER_12_249 VGND VGND VPWR VPWR sky130_fd_sc_hd__decap_3
XFILLER_100_65 VPWR VGND VPWR VGND sky130_ef_sc_hd__decap_12
XFILLER_106_365 VGND VGND VPWR VPWR sky130_fd_sc_hd__fill_1
XFILLER_87_260 VGND VGND VPWR VPWR sky130_fd_sc_hd__fill_1
XFILLER_47_113 VGND VGND VPWR VPWR sky130_fd_sc_hd__decap_8
XFILLER_16_533 VPWR VGND VPWR VGND sky130_ef_sc_hd__decap_12
XFILLER_31_503 VGND VGND VPWR VPWR sky130_fd_sc_hd__fill_1
XFILLER_43_374 VGND VGND VPWR VPWR sky130_fd_sc_hd__decap_3
XFILLER_11_260 VGND VGND VPWR VPWR sky130_fd_sc_hd__fill_2
XFILLER_7_275 VGND VGND VPWR VPWR sky130_fd_sc_hd__decap_4
Xhold209 lsu.load_fifo.queue\[4\]\[4\] VGND VGND VPWR VPWR net677 sky130_fd_sc_hd__dlygate4sd3_1
XFILLER_98_514 VPWR VGND VPWR VGND sky130_ef_sc_hd__decap_12
X_3330_ net610 net331 net175 VGND VGND VPWR VPWR _0940_ sky130_fd_sc_hd__mux2_1
X_5000_ clknet_leaf_31_clk _1055_ VGND VGND VPWR VPWR lsu.load_fifo.queue\[14\]\[21\]
+ sky130_fd_sc_hd__dfxtp_1
X_3261_ lsu.current_store_addr\[10\] net1196 net257 VGND VGND VPWR VPWR _0821_ sky130_fd_sc_hd__mux2_1
X_2212_ lsu.load_counter\[13\] _1692_ _1690_ VGND VGND VPWR VPWR _0918_ sky130_fd_sc_hd__o21ba_1
X_3192_ net871 net315 net202 VGND VGND VPWR VPWR _0693_ sky130_fd_sc_hd__mux2_1
X_2143_ net473 _1632_ VGND VGND VPWR VPWR _1633_ sky130_fd_sc_hd__and2_1
XFILLER_66_477 VGND VGND VPWR VPWR sky130_fd_sc_hd__fill_1
X_2074_ net8 _1563_ VGND VGND VPWR VPWR _1564_ sky130_fd_sc_hd__nor2_1
XTAP_TAPCELL_ROW_52_807 VGND VPWR sky130_fd_sc_hd__tapvpwrvgnd_1
X_2976_ net989 net348 net189 VGND VGND VPWR VPWR _0484_ sky130_fd_sc_hd__mux2_1
X_4715_ clknet_leaf_25_clk _0772_ VGND VGND VPWR VPWR net122 sky130_fd_sc_hd__dfxtp_1
XTAP_TAPCELL_ROW_32_586 VGND VPWR sky130_fd_sc_hd__tapvpwrvgnd_1
XTAP_TAPCELL_ROW_60_895 VGND VPWR sky130_fd_sc_hd__tapvpwrvgnd_1
X_4646_ clknet_leaf_13_clk _0703_ VGND VGND VPWR VPWR lsu.load_fifo.queue\[15\]\[30\]
+ sky130_fd_sc_hd__dfxtp_1
X_4577_ clknet_leaf_68_clk _0634_ VGND VGND VPWR VPWR lsu.load_fifo.queue\[0\]\[25\]
+ sky130_fd_sc_hd__dfxtp_1
Xhold721 lsu.store_fifo.queue\[4\]\[3\] VGND VGND VPWR VPWR net1189 sky130_fd_sc_hd__dlygate4sd3_1
Xhold710 lsu.store_fifo.queue\[5\]\[9\] VGND VGND VPWR VPWR net1178 sky130_fd_sc_hd__dlygate4sd3_1
Xhold754 lsu.load_fifo.queue\[13\]\[18\] VGND VGND VPWR VPWR net1222 sky130_fd_sc_hd__dlygate4sd3_1
Xhold732 lsu.store_fifo.queue\[8\]\[5\] VGND VGND VPWR VPWR net1200 sky130_fd_sc_hd__dlygate4sd3_1
Xhold743 lsu.store_fifo.queue\[3\]\[8\] VGND VGND VPWR VPWR net1211 sky130_fd_sc_hd__dlygate4sd3_1
XFILLER_89_547 VGND VGND VPWR VPWR sky130_fd_sc_hd__fill_1
X_3528_ net441 VGND VGND VPWR VPWR _0092_ sky130_fd_sc_hd__inv_2
XFILLER_1_429 VPWR VGND VPWR VGND sky130_ef_sc_hd__decap_12
Xhold776 net154 VGND VGND VPWR VPWR net1244 sky130_fd_sc_hd__dlygate4sd3_1
Xhold787 acc.byte2\[4\] VGND VGND VPWR VPWR net1255 sky130_fd_sc_hd__dlygate4sd3_1
Xhold765 lsu.store_fifo.queue\[5\]\[4\] VGND VGND VPWR VPWR net1233 sky130_fd_sc_hd__dlygate4sd3_1
X_3459_ net428 VGND VGND VPWR VPWR _0023_ sky130_fd_sc_hd__inv_2
Xhold798 acc.byte2\[6\] VGND VGND VPWR VPWR net1266 sky130_fd_sc_hd__dlygate4sd3_1
XFILLER_69_260 VGND VGND VPWR VPWR sky130_fd_sc_hd__decap_4
XFILLER_57_411 VGND VGND VPWR VPWR sky130_fd_sc_hd__decap_4
XFILLER_29_113 VGND VGND VPWR VPWR sky130_fd_sc_hd__decap_3
XTAP_TAPCELL_ROW_68_973 VGND VPWR sky130_fd_sc_hd__tapvpwrvgnd_1
XTAP_TAPCELL_ROW_4_278 VGND VPWR sky130_fd_sc_hd__tapvpwrvgnd_1
XFILLER_45_606 VGND VGND VPWR VPWR sky130_fd_sc_hd__fill_2
XFILLER_72_469 VGND VGND VPWR VPWR sky130_fd_sc_hd__decap_6
XTAP_TAPCELL_ROW_80_1106 VGND VPWR sky130_fd_sc_hd__tapvpwrvgnd_1
XFILLER_13_503 VGND VGND VPWR VPWR sky130_fd_sc_hd__fill_1
XFILLER_40_300 VGND VGND VPWR VPWR sky130_fd_sc_hd__decap_8
XFILLER_71_57 VGND VGND VPWR VPWR sky130_fd_sc_hd__fill_2
XFILLER_9_529 VPWR VGND VPWR VGND sky130_ef_sc_hd__decap_12
XTAP_TAPCELL_ROW_91_1235 VGND VPWR sky130_fd_sc_hd__tapvpwrvgnd_1
XFILLER_96_65 VPWR VGND VPWR VGND sky130_ef_sc_hd__decap_12
XFILLER_0_473 VGND VGND VPWR VPWR sky130_fd_sc_hd__decap_3
Xhold81 net108 VGND VGND VPWR VPWR net549 sky130_fd_sc_hd__dlygate4sd3_1
XFILLER_75_241 VGND VGND VPWR VPWR sky130_fd_sc_hd__fill_1
XFILLER_29_81 VGND VGND VPWR VPWR sky130_fd_sc_hd__decap_4
Xhold70 lsu.store_fifo.queue\[14\]\[8\] VGND VGND VPWR VPWR net538 sky130_fd_sc_hd__dlygate4sd3_1
Xhold92 lsu.store_fifo.queue\[12\]\[0\] VGND VGND VPWR VPWR net560 sky130_fd_sc_hd__dlygate4sd3_1
XFILLER_75_274 VGND VGND VPWR VPWR sky130_fd_sc_hd__decap_6
XFILLER_90_277 VPWR VGND VPWR VGND sky130_ef_sc_hd__decap_12
X_2830_ net307 net967 net229 VGND VGND VPWR VPWR _0343_ sky130_fd_sc_hd__mux2_1
XTAP_TAPCELL_ROW_100_1331 VGND VPWR sky130_fd_sc_hd__tapvpwrvgnd_1
X_2761_ net661 net290 _2028_ VGND VGND VPWR VPWR _0279_ sky130_fd_sc_hd__mux2_1
X_2692_ net543 net317 net230 VGND VGND VPWR VPWR _0216_ sky130_fd_sc_hd__mux2_1
X_4500_ clknet_leaf_18_clk _0557_ VGND VGND VPWR VPWR lsu.load_fifo.queue\[2\]\[12\]
+ sky130_fd_sc_hd__dfxtp_1
XANTENNA_1 _2042_ VGND VGND VPWR VPWR sky130_fd_sc_hd__diode_2
X_4431_ clknet_leaf_33_clk _0488_ VGND VGND VPWR VPWR lsu.load_fifo.queue\[4\]\[7\]
+ sky130_fd_sc_hd__dfxtp_1
X_4362_ clknet_leaf_20_clk _0419_ VGND VGND VPWR VPWR lsu.load_fifo.queue\[6\]\[2\]
+ sky130_fd_sc_hd__dfxtp_1
XFILLER_98_333 VPWR VGND VPWR VGND sky130_ef_sc_hd__decap_12
X_3313_ net1292 net67 net250 VGND VGND VPWR VPWR _0875_ sky130_fd_sc_hd__mux2_1
X_4293_ clknet_leaf_76_clk _0350_ VGND VGND VPWR VPWR lsu.load_fifo.queue\[9\]\[31\]
+ sky130_fd_sc_hd__dfxtp_1
X_3244_ net719 lsu.current_load_addr\[16\] net237 VGND VGND VPWR VPWR _0782_ sky130_fd_sc_hd__mux2_1
X_3175_ net690 net348 net202 VGND VGND VPWR VPWR _0676_ sky130_fd_sc_hd__mux2_1
XFILLER_27_617 VGND VGND VPWR VPWR sky130_fd_sc_hd__fill_1
Xrebuffer13 net16 VGND VGND VPWR VPWR net481 sky130_fd_sc_hd__dlymetal6s2s_1
X_2126_ _1599_ _1615_ VGND VGND VPWR VPWR _1616_ sky130_fd_sc_hd__nor2_1
XTAP_TAPCELL_ROW_1_237 VGND VPWR sky130_fd_sc_hd__tapvpwrvgnd_1
XFILLER_39_499 VGND VGND VPWR VPWR sky130_fd_sc_hd__decap_4
XFILLER_66_296 VGND VGND VPWR VPWR sky130_fd_sc_hd__decap_3
XFILLER_81_233 VGND VGND VPWR VPWR sky130_fd_sc_hd__decap_8
XFILLER_19_190 VGND VGND VPWR VPWR sky130_fd_sc_hd__fill_2
XTAP_TAPCELL_ROW_37_634 VGND VPWR sky130_fd_sc_hd__tapvpwrvgnd_1
XTAP_TAPCELL_ROW_65_943 VGND VPWR sky130_fd_sc_hd__tapvpwrvgnd_1
X_2959_ net312 net1148 net216 VGND VGND VPWR VPWR _0470_ sky130_fd_sc_hd__mux2_1
X_4629_ clknet_leaf_3_clk _0686_ VGND VGND VPWR VPWR lsu.load_fifo.queue\[15\]\[13\]
+ sky130_fd_sc_hd__dfxtp_1
XTAP_TAPCELL_ROW_9_326 VGND VPWR sky130_fd_sc_hd__tapvpwrvgnd_1
Xhold551 lsu.load_fifo.queue\[6\]\[3\] VGND VGND VPWR VPWR net1019 sky130_fd_sc_hd__dlygate4sd3_1
Xhold540 lsu.load_fifo.queue\[7\]\[22\] VGND VGND VPWR VPWR net1008 sky130_fd_sc_hd__dlygate4sd3_1
Xhold562 lsu.store_fifo.queue\[6\]\[2\] VGND VGND VPWR VPWR net1030 sky130_fd_sc_hd__dlygate4sd3_1
Xhold573 lsu.load_fifo.queue\[11\]\[21\] VGND VGND VPWR VPWR net1041 sky130_fd_sc_hd__dlygate4sd3_1
Xhold595 lsu.load_fifo.queue\[1\]\[25\] VGND VGND VPWR VPWR net1063 sky130_fd_sc_hd__dlygate4sd3_1
Xhold584 lsu.store_fifo.queue\[5\]\[3\] VGND VGND VPWR VPWR net1052 sky130_fd_sc_hd__dlygate4sd3_1
XFILLER_106_53 VGND VGND VPWR VPWR sky130_fd_sc_hd__decap_3
XFILLER_77_528 VGND VGND VPWR VPWR sky130_fd_sc_hd__fill_1
XFILLER_103_198 VGND VGND VPWR VPWR sky130_fd_sc_hd__decap_6
XFILLER_57_252 VGND VGND VPWR VPWR sky130_fd_sc_hd__fill_2
XFILLER_72_277 VPWR VGND VPWR VGND sky130_ef_sc_hd__decap_12
XFILLER_13_322 VGND VGND VPWR VPWR sky130_fd_sc_hd__decap_6
XFILLER_15_72 VGND VGND VPWR VPWR sky130_fd_sc_hd__decap_6
XFILLER_40_152 VGND VGND VPWR VPWR sky130_fd_sc_hd__fill_2
XFILLER_9_337 VGND VGND VPWR VPWR sky130_fd_sc_hd__decap_8
XFILLER_0_281 VGND VGND VPWR VPWR sky130_fd_sc_hd__decap_8
XFILLER_76_561 VGND VGND VPWR VPWR sky130_fd_sc_hd__decap_6
X_4980_ clknet_leaf_78_clk _1035_ VGND VGND VPWR VPWR lsu.load_fifo.queue\[14\]\[1\]
+ sky130_fd_sc_hd__dfxtp_1
XTAP_TAPCELL_ROW_34_604 VGND VPWR sky130_fd_sc_hd__tapvpwrvgnd_1
XTAP_TAPCELL_ROW_62_913 VGND VPWR sky130_fd_sc_hd__tapvpwrvgnd_1
XFILLER_63_266 VGND VGND VPWR VPWR sky130_fd_sc_hd__decap_4
X_3931_ net1300 _1381_ net254 VGND VGND VPWR VPWR _1012_ sky130_fd_sc_hd__mux2_1
X_3862_ lsu.load_fifo.queue\[8\]\[20\] lsu.load_fifo.queue\[9\]\[20\] lsu.load_fifo.queue\[10\]\[20\]
+ lsu.load_fifo.queue\[11\]\[20\] net384 net367 VGND VGND VPWR VPWR _1323_ sky130_fd_sc_hd__mux4_1
X_2813_ net340 net979 net229 VGND VGND VPWR VPWR _0326_ sky130_fd_sc_hd__mux2_1
XTAP_TAPCELL_ROW_14_383 VGND VPWR sky130_fd_sc_hd__tapvpwrvgnd_1
XTAP_TAPCELL_ROW_42_692 VGND VPWR sky130_fd_sc_hd__tapvpwrvgnd_1
X_3793_ lsu.load_fifo.queue\[8\]\[30\] lsu.load_fifo.queue\[9\]\[30\] lsu.load_fifo.queue\[10\]\[30\]
+ lsu.load_fifo.queue\[11\]\[30\] net395 net378 VGND VGND VPWR VPWR _1264_ sky130_fd_sc_hd__mux4_1
X_2744_ net931 net281 _2026_ VGND VGND VPWR VPWR _0264_ sky130_fd_sc_hd__mux2_1
X_2675_ net679 net350 net232 VGND VGND VPWR VPWR _0199_ sky130_fd_sc_hd__mux2_1
X_4414_ clknet_leaf_72_clk _0471_ VGND VGND VPWR VPWR lsu.load_fifo.queue\[5\]\[22\]
+ sky130_fd_sc_hd__dfxtp_1
Xfanout305 lsu.load_fifo.data_in\[25\] VGND VGND VPWR VPWR net305 sky130_fd_sc_hd__dlymetal6s2s_1
X_4345_ clknet_leaf_7_clk _0402_ VGND VGND VPWR VPWR lsu.load_fifo.queue\[7\]\[19\]
+ sky130_fd_sc_hd__dfxtp_1
XFILLER_101_614 VGND VGND VPWR VPWR sky130_fd_sc_hd__fill_2
XFILLER_98_141 VPWR VGND VPWR VGND sky130_ef_sc_hd__decap_12
Xfanout327 lsu.load_fifo.data_in\[14\] VGND VGND VPWR VPWR net327 sky130_fd_sc_hd__buf_1
Xfanout316 net317 VGND VGND VPWR VPWR net316 sky130_fd_sc_hd__clkbuf_2
Xfanout338 lsu.load_fifo.data_in\[8\] VGND VGND VPWR VPWR net338 sky130_fd_sc_hd__clkbuf_2
Xfanout349 lsu.load_fifo.data_in\[3\] VGND VGND VPWR VPWR net349 sky130_fd_sc_hd__dlymetal6s2s_1
X_4276_ clknet_leaf_3_clk _0333_ VGND VGND VPWR VPWR lsu.load_fifo.queue\[9\]\[14\]
+ sky130_fd_sc_hd__dfxtp_1
X_3227_ net437 _1778_ VGND VGND VPWR VPWR _2051_ sky130_fd_sc_hd__nor2_1
X_3158_ net562 net317 net177 VGND VGND VPWR VPWR _0660_ sky130_fd_sc_hd__mux2_1
X_2109_ _1590_ _1596_ _1598_ VGND VGND VPWR VPWR _1599_ sky130_fd_sc_hd__or3_4
XFILLER_15_609 VGND VGND VPWR VPWR sky130_fd_sc_hd__decap_6
XFILLER_27_447 VGND VGND VPWR VPWR sky130_fd_sc_hd__fill_1
XFILLER_27_458 VGND VGND VPWR VPWR sky130_fd_sc_hd__decap_3
X_3089_ net322 net1228 net188 VGND VGND VPWR VPWR _0593_ sky130_fd_sc_hd__mux2_1
XFILLER_22_141 VGND VGND VPWR VPWR sky130_fd_sc_hd__decap_4
XFILLER_10_303 VGND VGND VPWR VPWR sky130_fd_sc_hd__decap_4
XFILLER_2_513 VPWR VGND VPWR VGND sky130_ef_sc_hd__decap_12
Xhold370 lsu.load_fifo.queue\[11\]\[25\] VGND VGND VPWR VPWR net838 sky130_fd_sc_hd__dlygate4sd3_1
XFILLER_2_557 VPWR VGND VPWR VGND sky130_ef_sc_hd__decap_12
Xhold381 lsu.store_fifo.queue\[8\]\[8\] VGND VGND VPWR VPWR net849 sky130_fd_sc_hd__dlygate4sd3_1
XFILLER_104_474 VGND VGND VPWR VPWR sky130_fd_sc_hd__fill_2
XFILLER_77_314 VGND VGND VPWR VPWR sky130_fd_sc_hd__fill_2
Xhold392 lsu.load_fifo.queue\[0\]\[22\] VGND VGND VPWR VPWR net860 sky130_fd_sc_hd__dlygate4sd3_1
XFILLER_93_55 VGND VGND VPWR VPWR sky130_fd_sc_hd__fill_1
XFILLER_18_447 VPWR VGND VPWR VGND sky130_ef_sc_hd__decap_12
XTAP_TAPCELL_ROW_86_1178 VGND VPWR sky130_fd_sc_hd__tapvpwrvgnd_1
XFILLER_13_185 VGND VGND VPWR VPWR sky130_fd_sc_hd__fill_1
Xrebuffer4 net471 VGND VGND VPWR VPWR net472 sky130_fd_sc_hd__dlygate4sd1_1
XTAP_TAPCELL_ROW_11_353 VGND VPWR sky130_fd_sc_hd__tapvpwrvgnd_1
XTAP_TAPCELL_ROW_97_1296 VGND VPWR sky130_fd_sc_hd__tapvpwrvgnd_1
X_2460_ lsu.current_store_addr\[11\] _1884_ _1885_ net252 VGND VGND VPWR VPWR _0800_
+ sky130_fd_sc_hd__o22a_1
X_2391_ _1569_ _1779_ VGND VGND VPWR VPWR _1830_ sky130_fd_sc_hd__nor2_1
X_4130_ clknet_leaf_49_clk _0187_ VGND VGND VPWR VPWR lsu.store_fifo.queue\[10\]\[0\]
+ sky130_fd_sc_hd__dfxtp_1
XFILLER_95_111 VGND VGND VPWR VPWR sky130_fd_sc_hd__fill_1
XFILLER_95_133 VGND VGND VPWR VPWR sky130_fd_sc_hd__fill_1
X_4061_ net246 _1496_ VGND VGND VPWR VPWR _1497_ sky130_fd_sc_hd__nand2_1
XFILLER_83_328 VGND VGND VPWR VPWR sky130_fd_sc_hd__decap_3
X_3012_ net1068 net345 net212 VGND VGND VPWR VPWR _0518_ sky130_fd_sc_hd__mux2_1
XFILLER_64_531 VGND VGND VPWR VPWR sky130_fd_sc_hd__fill_1
XFILLER_64_542 VGND VGND VPWR VPWR sky130_fd_sc_hd__decap_4
XFILLER_91_361 VPWR VGND VPWR VGND sky130_ef_sc_hd__decap_12
XTAP_TAPCELL_ROW_19_442 VGND VPWR sky130_fd_sc_hd__tapvpwrvgnd_1
XTAP_TAPCELL_ROW_47_751 VGND VPWR sky130_fd_sc_hd__tapvpwrvgnd_1
XFILLER_36_299 VGND VGND VPWR VPWR sky130_fd_sc_hd__fill_1
X_4963_ clknet_leaf_33_clk _1018_ _0149_ VGND VGND VPWR VPWR acc.byte2\[0\] sky130_fd_sc_hd__dfrtp_1
XTAP_TAPCELL_ROW_106_1392 VGND VPWR sky130_fd_sc_hd__tapvpwrvgnd_1
XFILLER_51_247 VGND VGND VPWR VPWR sky130_fd_sc_hd__fill_1
X_3914_ lsu.load_fifo.queue\[12\]\[12\] lsu.load_fifo.queue\[13\]\[12\] lsu.load_fifo.queue\[14\]\[12\]
+ lsu.load_fifo.queue\[15\]\[12\] net391 net374 VGND VGND VPWR VPWR _1367_ sky130_fd_sc_hd__mux4_1
X_4894_ clknet_leaf_31_clk _0949_ VGND VGND VPWR VPWR lsu.load_fifo.queue\[12\]\[21\]
+ sky130_fd_sc_hd__dfxtp_1
XFILLER_20_601 VPWR VGND VPWR VGND sky130_ef_sc_hd__decap_12
XFILLER_32_483 VGND VGND VPWR VPWR sky130_fd_sc_hd__fill_2
XFILLER_22_29 VGND VGND VPWR VPWR sky130_fd_sc_hd__decap_3
X_3845_ lsu.load_fifo.queue\[12\]\[22\] lsu.load_fifo.queue\[13\]\[22\] lsu.load_fifo.queue\[14\]\[22\]
+ lsu.load_fifo.queue\[15\]\[22\] net389 net372 VGND VGND VPWR VPWR _1308_ sky130_fd_sc_hd__mux4_1
X_3776_ _1246_ _1247_ net361 VGND VGND VPWR VPWR _1248_ sky130_fd_sc_hd__mux2_1
X_2727_ net875 net273 _2025_ VGND VGND VPWR VPWR _0248_ sky130_fd_sc_hd__mux2_1
X_2658_ net275 net648 _2019_ VGND VGND VPWR VPWR _0185_ sky130_fd_sc_hd__mux2_1
X_2589_ net41 _1978_ net264 VGND VGND VPWR VPWR _1979_ sky130_fd_sc_hd__mux2_1
X_4328_ clknet_leaf_20_clk _0385_ VGND VGND VPWR VPWR lsu.load_fifo.queue\[7\]\[2\]
+ sky130_fd_sc_hd__dfxtp_1
Xfanout168 _1663_ VGND VGND VPWR VPWR net168 sky130_fd_sc_hd__buf_6
Xfanout179 _2046_ VGND VGND VPWR VPWR net179 sky130_fd_sc_hd__buf_4
X_4259_ clknet_leaf_67_clk _0316_ VGND VGND VPWR VPWR lsu.store_fifo.queue\[1\]\[7\]
+ sky130_fd_sc_hd__dfxtp_1
XFILLER_67_391 VGND VGND VPWR VPWR sky130_fd_sc_hd__fill_1
XFILLER_70_501 VPWR VGND VPWR VGND sky130_ef_sc_hd__decap_12
XFILLER_27_255 VPWR VGND VPWR VGND sky130_ef_sc_hd__decap_12
XFILLER_42_214 VGND VGND VPWR VPWR sky130_fd_sc_hd__fill_1
XFILLER_70_589 VGND VGND VPWR VPWR sky130_fd_sc_hd__fill_2
XFILLER_78_601 VGND VGND VPWR VPWR sky130_fd_sc_hd__decap_6
XFILLER_92_147 VGND VGND VPWR VPWR sky130_fd_sc_hd__fill_1
XFILLER_18_233 VGND VGND VPWR VPWR sky130_fd_sc_hd__fill_1
XFILLER_61_501 VGND VGND VPWR VPWR sky130_fd_sc_hd__decap_3
XTAP_TAPCELL_ROW_16_401 VGND VPWR sky130_fd_sc_hd__tapvpwrvgnd_1
XTAP_TAPCELL_ROW_44_710 VGND VPWR sky130_fd_sc_hd__tapvpwrvgnd_1
XTAP_TAPCELL_ROW_99_1314 VGND VPWR sky130_fd_sc_hd__tapvpwrvgnd_1
X_3630_ lsu.current_load_addr\[0\] VGND VGND VPWR VPWR _1113_ sky130_fd_sc_hd__inv_2
X_3561_ net431 VGND VGND VPWR VPWR _0125_ sky130_fd_sc_hd__inv_2
X_2512_ _1111_ net256 VGND VGND VPWR VPWR _0749_ sky130_fd_sc_hd__xnor2_1
XFILLER_52_3 VGND VGND VPWR VPWR sky130_fd_sc_hd__decap_8
X_3492_ net431 VGND VGND VPWR VPWR _0056_ sky130_fd_sc_hd__inv_2
X_2443_ _1853_ _1872_ net269 VGND VGND VPWR VPWR _1873_ sky130_fd_sc_hd__o21ai_1
X_2374_ lsu.store_counter\[0\] net2 _1639_ lsu.store_counter\[1\] VGND VGND VPWR VPWR
+ _1813_ sky130_fd_sc_hd__a22o_1
X_4113_ lsu.store_fifo.queue\[12\]\[0\] lsu.store_fifo.queue\[13\]\[0\] lsu.store_fifo.queue\[14\]\[0\]
+ lsu.store_fifo.queue\[15\]\[0\] net414 net410 VGND VGND VPWR VPWR _1544_ sky130_fd_sc_hd__mux4_1
XFILLER_96_475 VGND VGND VPWR VPWR sky130_fd_sc_hd__fill_1
XFILLER_49_391 VGND VGND VPWR VPWR sky130_fd_sc_hd__fill_1
X_4044_ net271 _1480_ VGND VGND VPWR VPWR _1481_ sky130_fd_sc_hd__nor2_1
Xclone9 _1666_ VGND VGND VPWR VPWR net477 sky130_fd_sc_hd__buf_6
XFILLER_83_169 VGND VGND VPWR VPWR sky130_fd_sc_hd__fill_1
X_4946_ clknet_leaf_66_clk _1001_ _0132_ VGND VGND VPWR VPWR net158 sky130_fd_sc_hd__dfrtp_1
XFILLER_52_589 VGND VGND VPWR VPWR sky130_fd_sc_hd__decap_6
XFILLER_32_280 VGND VGND VPWR VPWR sky130_fd_sc_hd__decap_6
X_4877_ clknet_leaf_18_clk _0932_ VGND VGND VPWR VPWR lsu.load_fifo.queue\[12\]\[4\]
+ sky130_fd_sc_hd__dfxtp_1
X_3828_ _1290_ _1293_ net357 VGND VGND VPWR VPWR _1294_ sky130_fd_sc_hd__mux2_1
XFILLER_20_453 VGND VGND VPWR VPWR sky130_fd_sc_hd__decap_6
XFILLER_20_475 VGND VGND VPWR VPWR sky130_fd_sc_hd__fill_1
XTAP_TAPCELL_ROW_50_779 VGND VPWR sky130_fd_sc_hd__tapvpwrvgnd_1
XFILLER_106_503 VGND VGND VPWR VPWR sky130_fd_sc_hd__fill_1
X_3759_ _1189_ _1227_ VGND VGND VPWR VPWR _1237_ sky130_fd_sc_hd__xnor2_1
XTAP_TAPCELL_ROW_72_1019 VGND VPWR sky130_fd_sc_hd__tapvpwrvgnd_1
XFILLER_101_241 VGND VGND VPWR VPWR sky130_fd_sc_hd__fill_2
XFILLER_28_531 VGND VGND VPWR VPWR sky130_fd_sc_hd__fill_1
XTAP_TAPCELL_ROW_58_868 VGND VPWR sky130_fd_sc_hd__tapvpwrvgnd_1
XFILLER_62_309 VGND VGND VPWR VPWR sky130_fd_sc_hd__fill_2
XFILLER_15_225 VGND VGND VPWR VPWR sky130_fd_sc_hd__decap_8
XFILLER_15_214 VGND VGND VPWR VPWR sky130_fd_sc_hd__fill_1
XTAP_TAPCELL_ROW_83_1148 VGND VPWR sky130_fd_sc_hd__tapvpwrvgnd_1
XFILLER_7_413 VPWR VGND VPWR VGND sky130_ef_sc_hd__decap_12
XFILLER_11_497 VGND VGND VPWR VPWR sky130_fd_sc_hd__decap_6
XFILLER_99_54 VGND VGND VPWR VPWR sky130_fd_sc_hd__fill_2
XTAP_TAPCELL_ROW_94_1266 VGND VPWR sky130_fd_sc_hd__tapvpwrvgnd_1
XFILLER_97_217 VGND VGND VPWR VPWR sky130_fd_sc_hd__decap_6
XFILLER_78_464 VGND VGND VPWR VPWR sky130_fd_sc_hd__fill_1
XFILLER_38_306 VGND VGND VPWR VPWR sky130_fd_sc_hd__fill_2
X_2090_ lsu.load_counter\[17\] _1565_ _1577_ VGND VGND VPWR VPWR _1580_ sky130_fd_sc_hd__and3_1
XFILLER_19_542 VGND VGND VPWR VPWR sky130_fd_sc_hd__decap_4
XFILLER_46_350 VGND VGND VPWR VPWR sky130_fd_sc_hd__fill_2
XFILLER_65_169 VPWR VGND VPWR VGND sky130_ef_sc_hd__decap_12
X_4800_ clknet_leaf_24_clk _0857_ VGND VGND VPWR VPWR lsu.load_fifo.data_in\[10\]
+ sky130_fd_sc_hd__dfxtp_1
XTAP_TAPCELL_ROW_103_1362 VGND VPWR sky130_fd_sc_hd__tapvpwrvgnd_1
X_2992_ net760 net316 net190 VGND VGND VPWR VPWR _0500_ sky130_fd_sc_hd__mux2_1
X_4731_ clknet_leaf_46_clk _0788_ _0045_ VGND VGND VPWR VPWR lsu.store_fifo.r_en sky130_fd_sc_hd__dfrtp_1
XFILLER_9_63 VGND VGND VPWR VPWR sky130_fd_sc_hd__fill_1
X_4662_ clknet_leaf_63_clk _0719_ VGND VGND VPWR VPWR lsu.store_fifo.queue\[15\]\[2\]
+ sky130_fd_sc_hd__dfxtp_1
X_3613_ lsu.load_counter\[22\] VGND VGND VPWR VPWR _1096_ sky130_fd_sc_hd__inv_2
X_4593_ clknet_leaf_78_clk _0650_ VGND VGND VPWR VPWR lsu.load_fifo.queue\[8\]\[9\]
+ sky130_fd_sc_hd__dfxtp_1
X_3544_ net438 VGND VGND VPWR VPWR _0108_ sky130_fd_sc_hd__inv_2
XFILLER_103_517 VGND VGND VPWR VPWR sky130_fd_sc_hd__fill_1
X_3475_ net424 VGND VGND VPWR VPWR _0039_ sky130_fd_sc_hd__inv_2
X_2426_ net92 _1860_ _1718_ VGND VGND VPWR VPWR _1861_ sky130_fd_sc_hd__mux2_1
X_2357_ _1788_ _1791_ _1795_ VGND VGND VPWR VPWR _1796_ sky130_fd_sc_hd__nor3_1
X_2288_ _1720_ _1732_ VGND VGND VPWR VPWR _1747_ sky130_fd_sc_hd__and2_1
XFILLER_72_629 VGND VGND VPWR VPWR sky130_fd_sc_hd__fill_1
XFILLER_25_501 VGND VGND VPWR VPWR sky130_fd_sc_hd__decap_3
XFILLER_44_309 VPWR VGND VPWR VGND sky130_ef_sc_hd__decap_12
X_4027_ net404 _1459_ _1461_ _1464_ _1465_ VGND VGND VPWR VPWR _1466_ sky130_fd_sc_hd__o32a_1
XTAP_TAPCELL_ROW_27_529 VGND VPWR sky130_fd_sc_hd__tapvpwrvgnd_1
XTAP_TAPCELL_ROW_55_838 VGND VPWR sky130_fd_sc_hd__tapvpwrvgnd_1
XFILLER_44_27 VGND VGND VPWR VPWR sky130_fd_sc_hd__fill_1
XFILLER_44_38 VGND VGND VPWR VPWR sky130_fd_sc_hd__decap_6
XFILLER_52_342 VGND VGND VPWR VPWR sky130_fd_sc_hd__fill_2
X_4929_ clknet_leaf_30_clk _0984_ VGND VGND VPWR VPWR lsu.load_fifo.queue\[13\]\[24\]
+ sky130_fd_sc_hd__dfxtp_1
XFILLER_12_228 VGND VGND VPWR VPWR sky130_fd_sc_hd__decap_4
XFILLER_100_77 VGND VGND VPWR VPWR sky130_fd_sc_hd__decap_6
XFILLER_106_399 VGND VGND VPWR VPWR sky130_fd_sc_hd__fill_1
XFILLER_94_209 VPWR VGND VPWR VGND sky130_ef_sc_hd__decap_12
XFILLER_75_423 VGND VGND VPWR VPWR sky130_fd_sc_hd__fill_1
XFILLER_35_309 VGND VGND VPWR VPWR sky130_fd_sc_hd__fill_2
XFILLER_47_169 VGND VGND VPWR VPWR sky130_fd_sc_hd__decap_6
XFILLER_16_501 VPWR VGND VPWR VGND sky130_ef_sc_hd__decap_12
XFILLER_18_94 VGND VGND VPWR VPWR sky130_fd_sc_hd__decap_6
XFILLER_16_545 VPWR VGND VPWR VGND sky130_ef_sc_hd__decap_12
XFILLER_16_589 VPWR VGND VPWR VGND sky130_ef_sc_hd__decap_12
XFILLER_70_194 VGND VGND VPWR VPWR sky130_fd_sc_hd__fill_2
XFILLER_31_559 VGND VGND VPWR VPWR sky130_fd_sc_hd__fill_1
XFILLER_50_70 VGND VGND VPWR VPWR sky130_fd_sc_hd__decap_3
XFILLER_98_526 VGND VGND VPWR VPWR sky130_fd_sc_hd__decap_3
XPHY_EDGE_ROW_0_Left_107 VGND VGND VPWR VPWR sky130_fd_sc_hd__decap_3
X_3260_ lsu.current_store_addr\[9\] net1156 net257 VGND VGND VPWR VPWR _0820_ sky130_fd_sc_hd__mux2_1
X_2211_ net479 net165 _1672_ net244 lsu.load_counter\[12\] VGND VGND VPWR VPWR _1692_
+ sky130_fd_sc_hd__o2111a_1
X_3191_ net727 net317 net202 VGND VGND VPWR VPWR _0692_ sky130_fd_sc_hd__mux2_1
X_2142_ net16 net2 net13 net17 VGND VGND VPWR VPWR _1632_ sky130_fd_sc_hd__o31ai_1
XFILLER_15_3 VGND VGND VPWR VPWR sky130_fd_sc_hd__decap_8
X_2073_ net7 net6 _1561_ net5 VGND VGND VPWR VPWR _1563_ sky130_fd_sc_hd__or4_4
XFILLER_26_309 VGND VGND VPWR VPWR sky130_fd_sc_hd__decap_8
X_4714_ clknet_leaf_25_clk _0771_ VGND VGND VPWR VPWR net121 sky130_fd_sc_hd__dfxtp_1
X_2975_ net634 net350 net191 VGND VGND VPWR VPWR _0483_ sky130_fd_sc_hd__mux2_1
XTAP_TAPCELL_ROW_32_587 VGND VPWR sky130_fd_sc_hd__tapvpwrvgnd_1
XTAP_TAPCELL_ROW_60_885 VGND VPWR sky130_fd_sc_hd__tapvpwrvgnd_1
X_4645_ clknet_leaf_23_clk _0702_ VGND VGND VPWR VPWR lsu.load_fifo.queue\[15\]\[29\]
+ sky130_fd_sc_hd__dfxtp_1
Xhold700 lsu.load_fifo.queue\[9\]\[29\] VGND VGND VPWR VPWR net1168 sky130_fd_sc_hd__dlygate4sd3_1
X_4576_ clknet_leaf_32_clk _0633_ VGND VGND VPWR VPWR lsu.load_fifo.queue\[0\]\[24\]
+ sky130_fd_sc_hd__dfxtp_1
Xhold711 lsu.load_fifo.queue\[13\]\[13\] VGND VGND VPWR VPWR net1179 sky130_fd_sc_hd__dlygate4sd3_1
X_3527_ net442 VGND VGND VPWR VPWR _0091_ sky130_fd_sc_hd__inv_2
Xhold722 lsu.load_fifo.queue\[1\]\[21\] VGND VGND VPWR VPWR net1190 sky130_fd_sc_hd__dlygate4sd3_1
Xhold755 lsu.load_fifo.queue\[12\]\[25\] VGND VGND VPWR VPWR net1223 sky130_fd_sc_hd__dlygate4sd3_1
Xhold733 lsu.load_fifo.queue\[5\]\[9\] VGND VGND VPWR VPWR net1201 sky130_fd_sc_hd__dlygate4sd3_1
Xhold744 lsu.load_fifo.queue\[9\]\[15\] VGND VGND VPWR VPWR net1212 sky130_fd_sc_hd__dlygate4sd3_1
Xhold766 lsu.store_fifo.queue\[3\]\[1\] VGND VGND VPWR VPWR net1234 sky130_fd_sc_hd__dlygate4sd3_1
Xhold788 acc.byte2\[3\] VGND VGND VPWR VPWR net1256 sky130_fd_sc_hd__dlygate4sd3_1
Xhold777 net155 VGND VGND VPWR VPWR net1245 sky130_fd_sc_hd__dlygate4sd3_1
X_3458_ net428 VGND VGND VPWR VPWR _0022_ sky130_fd_sc_hd__inv_2
Xhold799 acc.byte1\[5\] VGND VGND VPWR VPWR net1267 sky130_fd_sc_hd__dlygate4sd3_1
X_3389_ net892 net344 net198 VGND VGND VPWR VPWR _1039_ sky130_fd_sc_hd__mux2_1
X_2409_ _1109_ _1844_ VGND VGND VPWR VPWR _1845_ sky130_fd_sc_hd__nor2_1
XTAP_TAPCELL_ROW_68_974 VGND VPWR sky130_fd_sc_hd__tapvpwrvgnd_1
XTAP_TAPCELL_ROW_4_279 VGND VPWR sky130_fd_sc_hd__tapvpwrvgnd_1
XFILLER_45_629 VGND VGND VPWR VPWR sky130_fd_sc_hd__fill_1
XTAP_TAPCELL_ROW_80_1107 VGND VPWR sky130_fd_sc_hd__tapvpwrvgnd_1
XFILLER_25_353 VPWR VGND VPWR VGND sky130_ef_sc_hd__decap_12
XFILLER_25_375 VGND VGND VPWR VPWR sky130_fd_sc_hd__decap_6
XFILLER_13_559 VGND VGND VPWR VPWR sky130_fd_sc_hd__fill_1
XFILLER_106_141 VGND VGND VPWR VPWR sky130_fd_sc_hd__fill_1
XTAP_TAPCELL_ROW_91_1236 VGND VPWR sky130_fd_sc_hd__tapvpwrvgnd_1
XFILLER_96_77 VGND VGND VPWR VPWR sky130_fd_sc_hd__decap_6
Xhold60 lsu.load_fifo.queue\[8\]\[10\] VGND VGND VPWR VPWR net528 sky130_fd_sc_hd__dlygate4sd3_1
Xhold71 lsu.load_fifo.queue\[4\]\[10\] VGND VGND VPWR VPWR net539 sky130_fd_sc_hd__dlygate4sd3_1
Xhold82 lsu.load_fifo.queue\[12\]\[2\] VGND VGND VPWR VPWR net550 sky130_fd_sc_hd__dlygate4sd3_1
Xhold93 net124 VGND VGND VPWR VPWR net561 sky130_fd_sc_hd__dlygate4sd3_1
XFILLER_36_629 VGND VGND VPWR VPWR sky130_fd_sc_hd__fill_1
XPHY_EDGE_ROW_82_Left_189 VGND VGND VPWR VPWR sky130_fd_sc_hd__decap_3
XFILLER_90_289 VPWR VGND VPWR VGND sky130_ef_sc_hd__decap_12
XTAP_TAPCELL_ROW_100_1332 VGND VPWR sky130_fd_sc_hd__tapvpwrvgnd_1
XFILLER_12_581 VGND VGND VPWR VPWR sky130_fd_sc_hd__decap_6
X_2760_ _2014_ _2024_ VGND VGND VPWR VPWR _2028_ sky130_fd_sc_hd__nor2_4
X_2691_ net781 net319 net230 VGND VGND VPWR VPWR _0215_ sky130_fd_sc_hd__mux2_1
X_4430_ clknet_leaf_87_clk _0487_ VGND VGND VPWR VPWR lsu.load_fifo.queue\[4\]\[6\]
+ sky130_fd_sc_hd__dfxtp_1
XANTENNA_2 _2056_ VGND VGND VPWR VPWR sky130_fd_sc_hd__diode_2
XPHY_EDGE_ROW_91_Left_198 VGND VGND VPWR VPWR sky130_fd_sc_hd__decap_3
X_4361_ clknet_leaf_84_clk _0418_ VGND VGND VPWR VPWR lsu.load_fifo.queue\[6\]\[1\]
+ sky130_fd_sc_hd__dfxtp_1
XFILLER_98_345 VPWR VGND VPWR VGND sky130_ef_sc_hd__decap_12
X_3312_ net300 net66 net249 VGND VGND VPWR VPWR _0874_ sky130_fd_sc_hd__mux2_1
X_4292_ clknet_leaf_33_clk _0349_ VGND VGND VPWR VPWR lsu.load_fifo.queue\[9\]\[30\]
+ sky130_fd_sc_hd__dfxtp_1
X_3243_ net802 lsu.current_load_addr\[15\] net237 VGND VGND VPWR VPWR _0781_ sky130_fd_sc_hd__mux2_1
XFILLER_100_317 VGND VGND VPWR VPWR sky130_fd_sc_hd__fill_1
XFILLER_100_306 VGND VGND VPWR VPWR sky130_fd_sc_hd__fill_2
XFILLER_98_389 VGND VGND VPWR VPWR sky130_fd_sc_hd__decap_4
X_3174_ net591 net350 net204 VGND VGND VPWR VPWR _0675_ sky130_fd_sc_hd__mux2_1
XFILLER_66_253 VGND VGND VPWR VPWR sky130_fd_sc_hd__fill_2
X_2125_ lsu.load_counter\[8\] _1612_ _1613_ _1610_ _1611_ VGND VGND VPWR VPWR _1615_
+ sky130_fd_sc_hd__a2111o_1
XTAP_TAPCELL_ROW_1_238 VGND VPWR sky130_fd_sc_hd__tapvpwrvgnd_1
XFILLER_26_117 VGND VGND VPWR VPWR sky130_fd_sc_hd__fill_2
XFILLER_54_415 VGND VGND VPWR VPWR sky130_fd_sc_hd__decap_4
XFILLER_66_286 VGND VGND VPWR VPWR sky130_fd_sc_hd__fill_2
XFILLER_25_18 VGND VGND VPWR VPWR sky130_fd_sc_hd__fill_1
XTAP_TAPCELL_ROW_37_635 VGND VPWR sky130_fd_sc_hd__tapvpwrvgnd_1
XTAP_TAPCELL_ROW_65_944 VGND VPWR sky130_fd_sc_hd__tapvpwrvgnd_1
X_2958_ net314 net1137 net214 VGND VGND VPWR VPWR _0469_ sky130_fd_sc_hd__mux2_1
X_2889_ net639 net320 net194 VGND VGND VPWR VPWR _0400_ sky130_fd_sc_hd__mux2_1
X_4628_ clknet_leaf_19_clk _0685_ VGND VGND VPWR VPWR lsu.load_fifo.queue\[15\]\[12\]
+ sky130_fd_sc_hd__dfxtp_1
Xhold530 lsu.load_fifo.queue\[4\]\[28\] VGND VGND VPWR VPWR net998 sky130_fd_sc_hd__dlygate4sd3_1
XFILLER_104_601 VPWR VGND VPWR VGND sky130_ef_sc_hd__decap_12
XTAP_TAPCELL_ROW_77_1080 VGND VPWR sky130_fd_sc_hd__tapvpwrvgnd_1
X_4559_ clknet_leaf_32_clk _0616_ VGND VGND VPWR VPWR lsu.load_fifo.queue\[0\]\[7\]
+ sky130_fd_sc_hd__dfxtp_1
Xhold563 lsu.load_fifo.queue\[15\]\[27\] VGND VGND VPWR VPWR net1031 sky130_fd_sc_hd__dlygate4sd3_1
XTAP_TAPCELL_ROW_9_327 VGND VPWR sky130_fd_sc_hd__tapvpwrvgnd_1
Xhold541 lsu.store_fifo.queue\[2\]\[8\] VGND VGND VPWR VPWR net1009 sky130_fd_sc_hd__dlygate4sd3_1
Xhold552 lsu.store_fifo.queue\[15\]\[8\] VGND VGND VPWR VPWR net1020 sky130_fd_sc_hd__dlygate4sd3_1
Xhold574 lsu.load_fifo.queue\[9\]\[10\] VGND VGND VPWR VPWR net1042 sky130_fd_sc_hd__dlygate4sd3_1
Xhold585 lsu.store_fifo.queue\[11\]\[2\] VGND VGND VPWR VPWR net1053 sky130_fd_sc_hd__dlygate4sd3_1
Xhold596 lsu.load_fifo.queue\[14\]\[26\] VGND VGND VPWR VPWR net1064 sky130_fd_sc_hd__dlygate4sd3_1
XFILLER_49_209 VGND VGND VPWR VPWR sky130_fd_sc_hd__decap_6
XFILLER_18_629 VGND VGND VPWR VPWR sky130_fd_sc_hd__fill_1
XFILLER_45_404 VGND VGND VPWR VPWR sky130_fd_sc_hd__decap_3
XFILLER_45_437 VGND VGND VPWR VPWR sky130_fd_sc_hd__fill_2
XFILLER_60_418 VGND VGND VPWR VPWR sky130_fd_sc_hd__fill_2
XFILLER_40_197 VGND VGND VPWR VPWR sky130_fd_sc_hd__fill_2
XFILLER_95_337 VPWR VGND VPWR VGND sky130_ef_sc_hd__decap_12
XFILLER_48_242 VGND VGND VPWR VPWR sky130_fd_sc_hd__fill_1
XFILLER_48_253 VGND VGND VPWR VPWR sky130_fd_sc_hd__fill_2
XFILLER_56_80 VGND VGND VPWR VPWR sky130_fd_sc_hd__decap_4
XFILLER_91_565 VGND VGND VPWR VPWR sky130_fd_sc_hd__fill_1
X_3930_ _1378_ _1380_ _1377_ _1379_ net358 net364 VGND VGND VPWR VPWR _1381_ sky130_fd_sc_hd__mux4_1
XTAP_TAPCELL_ROW_34_605 VGND VPWR sky130_fd_sc_hd__tapvpwrvgnd_1
XTAP_TAPCELL_ROW_62_914 VGND VPWR sky130_fd_sc_hd__tapvpwrvgnd_1
XFILLER_16_183 VGND VGND VPWR VPWR sky130_fd_sc_hd__decap_4
X_3861_ lsu.load_fifo.queue\[12\]\[20\] lsu.load_fifo.queue\[13\]\[20\] lsu.load_fifo.queue\[14\]\[20\]
+ lsu.load_fifo.queue\[15\]\[20\] net384 net367 VGND VGND VPWR VPWR _1322_ sky130_fd_sc_hd__mux4_1
XFILLER_82_3 VPWR VGND VPWR VGND sky130_ef_sc_hd__decap_12
X_2812_ net343 net1194 net226 VGND VGND VPWR VPWR _0325_ sky130_fd_sc_hd__mux2_1
XFILLER_31_164 VGND VGND VPWR VPWR sky130_fd_sc_hd__decap_4
X_3792_ lsu.load_fifo.queue\[12\]\[30\] lsu.load_fifo.queue\[13\]\[30\] lsu.load_fifo.queue\[14\]\[30\]
+ lsu.load_fifo.queue\[15\]\[30\] net395 net378 VGND VGND VPWR VPWR _1263_ sky130_fd_sc_hd__mux4_1
XTAP_TAPCELL_ROW_14_384 VGND VPWR sky130_fd_sc_hd__tapvpwrvgnd_1
XTAP_TAPCELL_ROW_42_693 VGND VPWR sky130_fd_sc_hd__tapvpwrvgnd_1
X_2743_ net731 net282 _2026_ VGND VGND VPWR VPWR _0263_ sky130_fd_sc_hd__mux2_1
X_2674_ net1047 net352 net231 VGND VGND VPWR VPWR _0198_ sky130_fd_sc_hd__mux2_1
X_4413_ clknet_leaf_14_clk _0470_ VGND VGND VPWR VPWR lsu.load_fifo.queue\[5\]\[21\]
+ sky130_fd_sc_hd__dfxtp_1
X_4344_ clknet_leaf_1_clk _0401_ VGND VGND VPWR VPWR lsu.load_fifo.queue\[7\]\[18\]
+ sky130_fd_sc_hd__dfxtp_1
XFILLER_98_153 VPWR VGND VPWR VGND sky130_ef_sc_hd__decap_12
Xfanout306 lsu.load_fifo.data_in\[24\] VGND VGND VPWR VPWR net306 sky130_fd_sc_hd__clkbuf_2
Xfanout317 lsu.load_fifo.data_in\[19\] VGND VGND VPWR VPWR net317 sky130_fd_sc_hd__dlymetal6s2s_1
Xfanout328 lsu.load_fifo.data_in\[13\] VGND VGND VPWR VPWR net328 sky130_fd_sc_hd__clkbuf_2
Xfanout339 lsu.load_fifo.data_in\[8\] VGND VGND VPWR VPWR net339 sky130_fd_sc_hd__buf_1
X_4275_ clknet_leaf_2_clk _0332_ VGND VGND VPWR VPWR lsu.load_fifo.queue\[9\]\[13\]
+ sky130_fd_sc_hd__dfxtp_1
X_3226_ net508 net273 _2050_ VGND VGND VPWR VPWR _0762_ sky130_fd_sc_hd__mux2_1
X_3157_ net895 net319 net177 VGND VGND VPWR VPWR _0659_ sky130_fd_sc_hd__mux2_1
X_2108_ lsu.load_counter\[15\] _1586_ _1592_ _1595_ _1597_ VGND VGND VPWR VPWR _1598_
+ sky130_fd_sc_hd__o2111ai_1
XFILLER_27_437 VGND VGND VPWR VPWR sky130_fd_sc_hd__fill_1
X_3088_ net325 net1218 net188 VGND VGND VPWR VPWR _0592_ sky130_fd_sc_hd__mux2_1
XFILLER_35_470 VGND VGND VPWR VPWR sky130_fd_sc_hd__decap_6
XFILLER_54_289 VGND VGND VPWR VPWR sky130_fd_sc_hd__decap_3
XFILLER_52_27 VGND VGND VPWR VPWR sky130_fd_sc_hd__fill_1
XFILLER_89_131 VGND VGND VPWR VPWR sky130_fd_sc_hd__decap_4
Xhold360 lsu.load_fifo.queue\[3\]\[20\] VGND VGND VPWR VPWR net828 sky130_fd_sc_hd__dlygate4sd3_1
XFILLER_2_525 VGND VGND VPWR VPWR sky130_fd_sc_hd__decap_6
Xhold371 lsu.load_fifo.queue\[14\]\[22\] VGND VGND VPWR VPWR net839 sky130_fd_sc_hd__dlygate4sd3_1
XFILLER_2_569 VPWR VGND VPWR VGND sky130_ef_sc_hd__decap_12
Xhold382 lsu.load_fifo.queue\[2\]\[18\] VGND VGND VPWR VPWR net850 sky130_fd_sc_hd__dlygate4sd3_1
Xhold393 lsu.store_fifo.queue\[12\]\[6\] VGND VGND VPWR VPWR net861 sky130_fd_sc_hd__dlygate4sd3_1
XFILLER_77_57 VGND VGND VPWR VPWR sky130_fd_sc_hd__decap_6
XFILLER_92_307 VGND VGND VPWR VPWR sky130_fd_sc_hd__fill_1
XFILLER_45_201 VPWR VGND VPWR VGND sky130_ef_sc_hd__decap_12
XFILLER_58_595 VGND VGND VPWR VPWR sky130_fd_sc_hd__fill_1
XFILLER_85_381 VGND VGND VPWR VPWR sky130_fd_sc_hd__decap_4
XFILLER_18_459 VGND VGND VPWR VPWR sky130_fd_sc_hd__decap_8
XTAP_TAPCELL_ROW_86_1179 VGND VPWR sky130_fd_sc_hd__tapvpwrvgnd_1
XFILLER_33_418 VGND VGND VPWR VPWR sky130_fd_sc_hd__decap_4
XFILLER_45_278 VGND VGND VPWR VPWR sky130_fd_sc_hd__fill_2
XFILLER_9_113 VGND VGND VPWR VPWR sky130_fd_sc_hd__decap_4
Xrebuffer5 net475 VGND VGND VPWR VPWR net473 sky130_fd_sc_hd__dlygate4sd1_1
XTAP_TAPCELL_ROW_11_354 VGND VPWR sky130_fd_sc_hd__tapvpwrvgnd_1
XTAP_TAPCELL_ROW_97_1297 VGND VPWR sky130_fd_sc_hd__tapvpwrvgnd_1
X_2390_ _1787_ _1825_ _1827_ _1828_ VGND VGND VPWR VPWR _1829_ sky130_fd_sc_hd__a211o_1
XFILLER_68_326 VPWR VGND VPWR VGND sky130_ef_sc_hd__decap_12
X_4060_ net403 _1489_ _1491_ _1494_ _1495_ VGND VGND VPWR VPWR _1496_ sky130_fd_sc_hd__o32a_1
XFILLER_95_167 VGND VGND VPWR VPWR sky130_fd_sc_hd__fill_1
X_3011_ net518 net347 net212 VGND VGND VPWR VPWR _0517_ sky130_fd_sc_hd__mux2_1
XTAP_TAPCELL_ROW_19_443 VGND VPWR sky130_fd_sc_hd__tapvpwrvgnd_1
XFILLER_24_418 VGND VGND VPWR VPWR sky130_fd_sc_hd__fill_2
XFILLER_36_278 VGND VGND VPWR VPWR sky130_fd_sc_hd__decap_4
XTAP_TAPCELL_ROW_47_752 VGND VPWR sky130_fd_sc_hd__tapvpwrvgnd_1
XFILLER_91_373 VGND VGND VPWR VPWR sky130_fd_sc_hd__decap_4
X_4962_ clknet_leaf_11_clk _1017_ _0148_ VGND VGND VPWR VPWR acc.byte1\[7\] sky130_fd_sc_hd__dfrtp_1
XTAP_TAPCELL_ROW_106_1393 VGND VPWR sky130_fd_sc_hd__tapvpwrvgnd_1
X_4893_ clknet_leaf_84_clk _0948_ VGND VGND VPWR VPWR lsu.load_fifo.queue\[12\]\[20\]
+ sky130_fd_sc_hd__dfxtp_1
XFILLER_32_440 VGND VGND VPWR VPWR sky130_fd_sc_hd__decap_8
X_3913_ lsu.load_fifo.queue\[0\]\[12\] lsu.load_fifo.queue\[1\]\[12\] lsu.load_fifo.queue\[2\]\[12\]
+ lsu.load_fifo.queue\[3\]\[12\] net392 net375 VGND VGND VPWR VPWR _1366_ sky130_fd_sc_hd__mux4_1
XFILLER_20_613 VPWR VGND VPWR VGND sky130_ef_sc_hd__decap_12
X_3844_ lsu.load_fifo.queue\[8\]\[22\] lsu.load_fifo.queue\[9\]\[22\] lsu.load_fifo.queue\[10\]\[22\]
+ lsu.load_fifo.queue\[11\]\[22\] net389 net372 VGND VGND VPWR VPWR _1307_ sky130_fd_sc_hd__mux4_1
X_3775_ lsu.load_fifo.queue\[12\]\[31\] lsu.load_fifo.queue\[13\]\[31\] lsu.load_fifo.queue\[14\]\[31\]
+ lsu.load_fifo.queue\[15\]\[31\] net389 net372 VGND VGND VPWR VPWR _1247_ sky130_fd_sc_hd__mux4_1
X_2726_ net849 net274 _2025_ VGND VGND VPWR VPWR _0247_ sky130_fd_sc_hd__mux2_1
X_2657_ net276 net1119 _2019_ VGND VGND VPWR VPWR _0184_ sky130_fd_sc_hd__mux2_1
X_2588_ lsu.current_load_addr\[5\] _1922_ VGND VGND VPWR VPWR _1978_ sky130_fd_sc_hd__xnor2_1
XFILLER_99_484 VGND VGND VPWR VPWR sky130_fd_sc_hd__fill_2
XFILLER_86_123 VGND VGND VPWR VPWR sky130_fd_sc_hd__fill_1
X_4327_ clknet_leaf_84_clk _0384_ VGND VGND VPWR VPWR lsu.load_fifo.queue\[7\]\[1\]
+ sky130_fd_sc_hd__dfxtp_1
Xfanout169 _2056_ VGND VGND VPWR VPWR net169 sky130_fd_sc_hd__buf_4
X_4258_ clknet_leaf_50_clk _0315_ VGND VGND VPWR VPWR lsu.store_fifo.queue\[1\]\[6\]
+ sky130_fd_sc_hd__dfxtp_1
XFILLER_86_189 VGND VGND VPWR VPWR sky130_fd_sc_hd__decap_6
XFILLER_74_329 VPWR VGND VPWR VGND sky130_ef_sc_hd__decap_12
X_3209_ net285 net958 _2049_ VGND VGND VPWR VPWR _0720_ sky130_fd_sc_hd__mux2_1
X_4189_ clknet_leaf_66_clk _0246_ VGND VGND VPWR VPWR lsu.store_fifo.queue\[8\]\[7\]
+ sky130_fd_sc_hd__dfxtp_1
XFILLER_27_223 VGND VGND VPWR VPWR sky130_fd_sc_hd__fill_1
XFILLER_103_55 VGND VGND VPWR VPWR sky130_fd_sc_hd__fill_1
XFILLER_27_267 VGND VGND VPWR VPWR sky130_fd_sc_hd__decap_3
XFILLER_103_88 VGND VGND VPWR VPWR sky130_fd_sc_hd__decap_4
XFILLER_70_513 VPWR VGND VPWR VGND sky130_ef_sc_hd__decap_12
XFILLER_10_134 VGND VGND VPWR VPWR sky130_fd_sc_hd__decap_6
XFILLER_7_617 VPWR VGND VPWR VGND sky130_ef_sc_hd__decap_12
Xhold190 lsu.load_fifo.queue\[8\]\[16\] VGND VGND VPWR VPWR net658 sky130_fd_sc_hd__dlygate4sd3_1
XFILLER_77_167 VGND VGND VPWR VPWR sky130_fd_sc_hd__fill_1
XPHY_EDGE_ROW_16_Right_16 VGND VGND VPWR VPWR sky130_fd_sc_hd__decap_3
XTAP_TAPCELL_ROW_16_402 VGND VPWR sky130_fd_sc_hd__tapvpwrvgnd_1
XTAP_TAPCELL_ROW_44_711 VGND VPWR sky130_fd_sc_hd__tapvpwrvgnd_1
XFILLER_61_535 VGND VGND VPWR VPWR sky130_fd_sc_hd__decap_6
XTAP_TAPCELL_ROW_99_1315 VGND VPWR sky130_fd_sc_hd__tapvpwrvgnd_1
XTAP_TAPCELL_ROW_24_490 VGND VPWR sky130_fd_sc_hd__tapvpwrvgnd_1
XPHY_EDGE_ROW_25_Right_25 VGND VGND VPWR VPWR sky130_fd_sc_hd__decap_3
X_3560_ net431 VGND VGND VPWR VPWR _0124_ sky130_fd_sc_hd__inv_2
X_2511_ _1915_ _1918_ VGND VGND VPWR VPWR _0750_ sky130_fd_sc_hd__nor2_1
X_3491_ net431 VGND VGND VPWR VPWR _0055_ sky130_fd_sc_hd__inv_2
X_2442_ lsu.current_store_addr\[15\] _1852_ VGND VGND VPWR VPWR _1872_ sky130_fd_sc_hd__nor2_1
XFILLER_45_3 VGND VGND VPWR VPWR sky130_fd_sc_hd__decap_6
X_2373_ lsu.store_counter\[1\] _1639_ VGND VGND VPWR VPWR _1812_ sky130_fd_sc_hd__nor2_1
X_4112_ net401 _1542_ VGND VGND VPWR VPWR _1543_ sky130_fd_sc_hd__or2_1
XFILLER_68_189 VGND VGND VPWR VPWR sky130_fd_sc_hd__fill_1
XFILLER_56_307 VGND VGND VPWR VPWR sky130_fd_sc_hd__fill_1
XFILLER_56_329 VGND VGND VPWR VPWR sky130_fd_sc_hd__decap_4
X_4043_ lsu.store_fifo.queue\[8\]\[6\] lsu.store_fifo.queue\[9\]\[6\] lsu.store_fifo.queue\[10\]\[6\]
+ lsu.store_fifo.queue\[11\]\[6\] net414 net410 VGND VGND VPWR VPWR _1480_ sky130_fd_sc_hd__mux4_1
XPHY_EDGE_ROW_34_Right_34 VGND VGND VPWR VPWR sky130_fd_sc_hd__decap_3
XFILLER_64_351 VGND VGND VPWR VPWR sky130_fd_sc_hd__fill_2
XFILLER_64_362 VGND VGND VPWR VPWR sky130_fd_sc_hd__fill_2
XFILLER_91_181 VPWR VGND VPWR VGND sky130_ef_sc_hd__decap_12
X_4945_ clknet_leaf_62_clk _1000_ _0131_ VGND VGND VPWR VPWR net157 sky130_fd_sc_hd__dfrtp_1
X_4876_ clknet_leaf_87_clk _0931_ VGND VGND VPWR VPWR lsu.load_fifo.queue\[12\]\[3\]
+ sky130_fd_sc_hd__dfxtp_1
X_3827_ _1292_ _1291_ net361 VGND VGND VPWR VPWR _1293_ sky130_fd_sc_hd__mux2_1
XPHY_EDGE_ROW_43_Right_43 VGND VGND VPWR VPWR sky130_fd_sc_hd__decap_3
X_3758_ net279 _1126_ _1236_ VGND VGND VPWR VPWR _1082_ sky130_fd_sc_hd__a21o_1
X_2709_ net285 net1193 _2023_ VGND VGND VPWR VPWR _0232_ sky130_fd_sc_hd__mux2_1
X_3689_ _1164_ _1169_ VGND VGND VPWR VPWR _1171_ sky130_fd_sc_hd__xnor2_1
XFILLER_87_421 VPWR VGND VPWR VGND sky130_ef_sc_hd__decap_12
XPHY_EDGE_ROW_52_Right_52 VGND VGND VPWR VPWR sky130_fd_sc_hd__decap_3
XTAP_TAPCELL_ROW_58_869 VGND VPWR sky130_fd_sc_hd__tapvpwrvgnd_1
XTAP_TAPCELL_ROW_83_1138 VGND VPWR sky130_fd_sc_hd__tapvpwrvgnd_1
XPHY_EDGE_ROW_61_Right_61 VGND VGND VPWR VPWR sky130_fd_sc_hd__decap_3
XFILLER_7_425 VPWR VGND VPWR VGND sky130_ef_sc_hd__decap_12
XTAP_TAPCELL_ROW_21_460 VGND VPWR sky130_fd_sc_hd__tapvpwrvgnd_1
XTAP_TAPCELL_ROW_94_1267 VGND VPWR sky130_fd_sc_hd__tapvpwrvgnd_1
XPHY_EDGE_ROW_70_Right_70 VGND VGND VPWR VPWR sky130_fd_sc_hd__decap_3
XFILLER_38_318 VPWR VGND VPWR VGND sky130_ef_sc_hd__decap_12
XFILLER_93_424 VGND VGND VPWR VPWR sky130_fd_sc_hd__fill_1
XFILLER_65_148 VGND VGND VPWR VPWR sky130_fd_sc_hd__decap_4
XFILLER_46_362 VGND VGND VPWR VPWR sky130_fd_sc_hd__fill_2
X_2991_ net870 net319 net189 VGND VGND VPWR VPWR _0499_ sky130_fd_sc_hd__mux2_1
X_4730_ clknet_leaf_39_clk net586 VGND VGND VPWR VPWR net117 sky130_fd_sc_hd__dfxtp_1
XTAP_TAPCELL_ROW_103_1363 VGND VPWR sky130_fd_sc_hd__tapvpwrvgnd_1
X_4661_ clknet_leaf_64_clk _0718_ VGND VGND VPWR VPWR lsu.store_fifo.queue\[15\]\[1\]
+ sky130_fd_sc_hd__dfxtp_1
X_3612_ net434 VGND VGND VPWR VPWR _0176_ sky130_fd_sc_hd__inv_2
X_4592_ clknet_leaf_54_clk _0649_ VGND VGND VPWR VPWR lsu.load_fifo.queue\[8\]\[8\]
+ sky130_fd_sc_hd__dfxtp_1
X_3543_ net438 VGND VGND VPWR VPWR _0107_ sky130_fd_sc_hd__inv_2
X_3474_ net435 VGND VGND VPWR VPWR _0038_ sky130_fd_sc_hd__inv_2
X_2425_ _1856_ _1859_ VGND VGND VPWR VPWR _1860_ sky130_fd_sc_hd__nor2_1
XFILLER_69_421 VPWR VGND VPWR VGND sky130_ef_sc_hd__decap_12
XFILLER_96_251 VGND VGND VPWR VPWR sky130_fd_sc_hd__fill_1
X_2356_ lsu.store_counter\[13\] _1594_ _1792_ _1794_ VGND VGND VPWR VPWR _1795_ sky130_fd_sc_hd__o211ai_1
XFILLER_28_29 VGND VGND VPWR VPWR sky130_fd_sc_hd__decap_4
X_2287_ net267 _1732_ net241 VGND VGND VPWR VPWR _1746_ sky130_fd_sc_hd__o21ai_1
XFILLER_56_126 VGND VGND VPWR VPWR sky130_fd_sc_hd__fill_1
XFILLER_56_137 VGND VGND VPWR VPWR sky130_fd_sc_hd__decap_3
X_4026_ net401 _1462_ net404 VGND VGND VPWR VPWR _1465_ sky130_fd_sc_hd__o21ai_1
XFILLER_25_513 VPWR VGND VPWR VGND sky130_ef_sc_hd__decap_12
XTAP_TAPCELL_ROW_55_839 VGND VPWR sky130_fd_sc_hd__tapvpwrvgnd_1
XFILLER_25_579 VPWR VGND VPWR VGND sky130_ef_sc_hd__decap_12
X_4928_ clknet_leaf_80_clk _0983_ VGND VGND VPWR VPWR lsu.load_fifo.queue\[13\]\[23\]
+ sky130_fd_sc_hd__dfxtp_1
X_4859_ clknet_leaf_39_clk _0914_ _0109_ VGND VGND VPWR VPWR lsu.load_counter\[9\]
+ sky130_fd_sc_hd__dfrtp_1
Xclkbuf_3_0__f_clk clknet_0_clk VGND VGND VPWR VPWR clknet_3_0__leaf_clk sky130_fd_sc_hd__clkbuf_16
XFILLER_106_301 VGND VGND VPWR VPWR sky130_fd_sc_hd__fill_1
XFILLER_106_356 VGND VGND VPWR VPWR sky130_fd_sc_hd__decap_4
XFILLER_0_601 VPWR VGND VPWR VGND sky130_ef_sc_hd__decap_12
XFILLER_47_148 VGND VGND VPWR VPWR sky130_fd_sc_hd__fill_1
XFILLER_16_513 VPWR VGND VPWR VGND sky130_ef_sc_hd__decap_12
XFILLER_16_557 VPWR VGND VPWR VGND sky130_ef_sc_hd__decap_12
Xclkbuf_leaf_82_clk clknet_3_1__leaf_clk VGND VGND VPWR VPWR clknet_leaf_82_clk sky130_fd_sc_hd__clkbuf_8
XFILLER_7_233 VPWR VGND VPWR VGND sky130_ef_sc_hd__decap_12
XFILLER_3_461 VPWR VGND VPWR VGND sky130_ef_sc_hd__decap_12
X_2210_ _1100_ _1690_ _1691_ net483 VGND VGND VPWR VPWR _0919_ sky130_fd_sc_hd__a2bb2o_4
X_3190_ net965 net318 net202 VGND VGND VPWR VPWR _0691_ sky130_fd_sc_hd__mux2_1
X_2141_ _1621_ _1629_ _1630_ VGND VGND VPWR VPWR _1631_ sky130_fd_sc_hd__nand3_1
XFILLER_78_273 VGND VGND VPWR VPWR sky130_fd_sc_hd__fill_1
XFILLER_38_137 VGND VGND VPWR VPWR sky130_fd_sc_hd__decap_3
X_2072_ net6 net5 _1561_ VGND VGND VPWR VPWR _1562_ sky130_fd_sc_hd__or3_1
XFILLER_81_449 VGND VGND VPWR VPWR sky130_fd_sc_hd__fill_1
Xclkbuf_leaf_73_clk clknet_3_4__leaf_clk VGND VGND VPWR VPWR clknet_leaf_73_clk sky130_fd_sc_hd__clkbuf_8
XFILLER_61_151 VGND VGND VPWR VPWR sky130_fd_sc_hd__fill_1
X_2974_ net942 net353 net189 VGND VGND VPWR VPWR _0482_ sky130_fd_sc_hd__mux2_1
X_4713_ clknet_leaf_29_clk _0770_ VGND VGND VPWR VPWR net120 sky130_fd_sc_hd__dfxtp_1
XPHY_EDGE_ROW_101_Left_208 VGND VGND VPWR VPWR sky130_fd_sc_hd__decap_3
XTAP_TAPCELL_ROW_32_577 VGND VPWR sky130_fd_sc_hd__tapvpwrvgnd_1
XTAP_TAPCELL_ROW_60_886 VGND VPWR sky130_fd_sc_hd__tapvpwrvgnd_1
X_4644_ clknet_leaf_16_clk _0701_ VGND VGND VPWR VPWR lsu.load_fifo.queue\[15\]\[28\]
+ sky130_fd_sc_hd__dfxtp_1
Xhold701 lsu.load_fifo.queue\[13\]\[0\] VGND VGND VPWR VPWR net1169 sky130_fd_sc_hd__dlygate4sd3_1
X_4575_ clknet_leaf_68_clk _0632_ VGND VGND VPWR VPWR lsu.load_fifo.queue\[0\]\[23\]
+ sky130_fd_sc_hd__dfxtp_1
Xhold712 lsu.load_fifo.queue\[9\]\[30\] VGND VGND VPWR VPWR net1180 sky130_fd_sc_hd__dlygate4sd3_1
XFILLER_89_505 VPWR VGND VPWR VGND sky130_ef_sc_hd__decap_12
X_3526_ net440 VGND VGND VPWR VPWR _0090_ sky130_fd_sc_hd__inv_2
Xhold734 lsu.store_fifo.queue\[7\]\[9\] VGND VGND VPWR VPWR net1202 sky130_fd_sc_hd__dlygate4sd3_1
Xhold745 lsu.store_fifo.queue\[3\]\[5\] VGND VGND VPWR VPWR net1213 sky130_fd_sc_hd__dlygate4sd3_1
Xhold723 lsu.load_fifo.queue\[1\]\[12\] VGND VGND VPWR VPWR net1191 sky130_fd_sc_hd__dlygate4sd3_1
XFILLER_103_315 VGND VGND VPWR VPWR sky130_fd_sc_hd__decap_3
Xhold756 lsu.load_fifo.queue\[5\]\[24\] VGND VGND VPWR VPWR net1224 sky130_fd_sc_hd__dlygate4sd3_1
Xhold767 lsu.load_fifo.queue\[9\]\[17\] VGND VGND VPWR VPWR net1235 sky130_fd_sc_hd__dlygate4sd3_1
Xhold778 net150 VGND VGND VPWR VPWR net1246 sky130_fd_sc_hd__dlygate4sd3_1
X_3457_ net428 VGND VGND VPWR VPWR _0021_ sky130_fd_sc_hd__inv_2
Xhold789 acc.byte3\[0\] VGND VGND VPWR VPWR net1257 sky130_fd_sc_hd__dlygate4sd3_1
X_2408_ lsu.current_store_addr\[4\] _1842_ VGND VGND VPWR VPWR _1844_ sky130_fd_sc_hd__nand2_1
X_3388_ net613 net346 net200 VGND VGND VPWR VPWR _1038_ sky130_fd_sc_hd__mux2_1
X_2339_ _1108_ _1778_ net264 VGND VGND VPWR VPWR _0836_ sky130_fd_sc_hd__a21oi_1
XFILLER_84_232 VGND VGND VPWR VPWR sky130_fd_sc_hd__decap_3
XTAP_TAPCELL_ROW_68_975 VGND VPWR sky130_fd_sc_hd__tapvpwrvgnd_1
XPHY_EDGE_ROW_2_Right_2 VGND VGND VPWR VPWR sky130_fd_sc_hd__decap_3
XTAP_TAPCELL_ROW_4_269 VGND VPWR sky130_fd_sc_hd__tapvpwrvgnd_1
XFILLER_29_137 VGND VGND VPWR VPWR sky130_fd_sc_hd__fill_1
X_4009_ net400 _1448_ VGND VGND VPWR VPWR _1449_ sky130_fd_sc_hd__nor2_1
Xclkbuf_leaf_64_clk clknet_3_5__leaf_clk VGND VGND VPWR VPWR clknet_leaf_64_clk sky130_fd_sc_hd__clkbuf_8
XTAP_TAPCELL_ROW_80_1108 VGND VPWR sky130_fd_sc_hd__tapvpwrvgnd_1
XFILLER_13_505 VPWR VGND VPWR VGND sky130_ef_sc_hd__decap_12
XFILLER_25_365 VGND VGND VPWR VPWR sky130_fd_sc_hd__fill_1
XFILLER_80_493 VGND VGND VPWR VPWR sky130_fd_sc_hd__fill_1
XFILLER_25_387 VGND VGND VPWR VPWR sky130_fd_sc_hd__decap_4
XTAP_TAPCELL_ROW_91_1226 VGND VPWR sky130_fd_sc_hd__tapvpwrvgnd_1
XFILLER_106_197 VGND VGND VPWR VPWR sky130_fd_sc_hd__fill_2
XFILLER_95_508 VGND VGND VPWR VPWR sky130_fd_sc_hd__decap_8
Xhold50 lsu.load_fifo.queue\[3\]\[4\] VGND VGND VPWR VPWR net518 sky130_fd_sc_hd__dlygate4sd3_1
Xhold83 lsu.load_fifo.queue\[7\]\[21\] VGND VGND VPWR VPWR net551 sky130_fd_sc_hd__dlygate4sd3_1
Xhold72 lsu.store_fifo.queue\[8\]\[0\] VGND VGND VPWR VPWR net540 sky130_fd_sc_hd__dlygate4sd3_1
XFILLER_29_94 VGND VGND VPWR VPWR sky130_fd_sc_hd__fill_2
Xhold61 lsu.store_fifo.queue\[4\]\[1\] VGND VGND VPWR VPWR net529 sky130_fd_sc_hd__dlygate4sd3_1
Xhold94 lsu.load_fifo.queue\[8\]\[19\] VGND VGND VPWR VPWR net562 sky130_fd_sc_hd__dlygate4sd3_1
Xclkbuf_leaf_55_clk clknet_3_4__leaf_clk VGND VGND VPWR VPWR clknet_leaf_55_clk sky130_fd_sc_hd__clkbuf_8
XFILLER_16_365 VGND VGND VPWR VPWR sky130_fd_sc_hd__fill_1
XFILLER_31_302 VGND VGND VPWR VPWR sky130_fd_sc_hd__fill_1
XTAP_TAPCELL_ROW_100_1333 VGND VPWR sky130_fd_sc_hd__tapvpwrvgnd_1
XFILLER_8_531 VGND VGND VPWR VPWR sky130_fd_sc_hd__fill_1
X_2690_ net774 net320 net231 VGND VGND VPWR VPWR _0214_ sky130_fd_sc_hd__mux2_1
XANTENNA_3 _2057_ VGND VGND VPWR VPWR sky130_fd_sc_hd__diode_2
XFILLER_6_54 VPWR VGND VPWR VGND sky130_ef_sc_hd__decap_12
X_4360_ clknet_leaf_33_clk _0417_ VGND VGND VPWR VPWR lsu.load_fifo.queue\[6\]\[0\]
+ sky130_fd_sc_hd__dfxtp_1
X_3311_ net1250 net65 net250 VGND VGND VPWR VPWR _0873_ sky130_fd_sc_hd__mux2_1
XFILLER_98_357 VGND VGND VPWR VPWR sky130_fd_sc_hd__decap_4
X_4291_ clknet_leaf_27_clk _0348_ VGND VGND VPWR VPWR lsu.load_fifo.queue\[9\]\[29\]
+ sky130_fd_sc_hd__dfxtp_1
X_3242_ net953 lsu.current_load_addr\[14\] net237 VGND VGND VPWR VPWR _0780_ sky130_fd_sc_hd__mux2_1
XFILLER_86_519 VGND VGND VPWR VPWR sky130_fd_sc_hd__decap_8
X_3173_ net832 net352 net202 VGND VGND VPWR VPWR _0674_ sky130_fd_sc_hd__mux2_1
X_2124_ _1613_ VGND VGND VPWR VPWR _1614_ sky130_fd_sc_hd__inv_2
XTAP_TAPCELL_ROW_1_239 VGND VPWR sky130_fd_sc_hd__tapvpwrvgnd_1
Xclkbuf_leaf_46_clk clknet_3_7__leaf_clk VGND VGND VPWR VPWR clknet_leaf_46_clk sky130_fd_sc_hd__clkbuf_8
XTAP_TAPCELL_ROW_37_636 VGND VPWR sky130_fd_sc_hd__tapvpwrvgnd_1
XTAP_TAPCELL_ROW_65_945 VGND VPWR sky130_fd_sc_hd__tapvpwrvgnd_1
XFILLER_81_268 VPWR VGND VPWR VGND sky130_ef_sc_hd__decap_12
X_2957_ net316 net1078 net214 VGND VGND VPWR VPWR _0468_ sky130_fd_sc_hd__mux2_1
X_2888_ net829 net322 net196 VGND VGND VPWR VPWR _0399_ sky130_fd_sc_hd__mux2_1
X_4627_ clknet_leaf_85_clk _0684_ VGND VGND VPWR VPWR lsu.load_fifo.queue\[15\]\[11\]
+ sky130_fd_sc_hd__dfxtp_1
Xhold520 lsu.load_fifo.queue\[1\]\[17\] VGND VGND VPWR VPWR net988 sky130_fd_sc_hd__dlygate4sd3_1
XFILLER_104_613 VPWR VGND VPWR VGND sky130_ef_sc_hd__decap_12
Xhold531 lsu.load_fifo.queue\[2\]\[16\] VGND VGND VPWR VPWR net999 sky130_fd_sc_hd__dlygate4sd3_1
XTAP_TAPCELL_ROW_77_1081 VGND VPWR sky130_fd_sc_hd__tapvpwrvgnd_1
Xhold542 lsu.load_fifo.queue\[7\]\[2\] VGND VGND VPWR VPWR net1010 sky130_fd_sc_hd__dlygate4sd3_1
X_4558_ clknet_leaf_1_clk _0615_ VGND VGND VPWR VPWR lsu.load_fifo.queue\[0\]\[6\]
+ sky130_fd_sc_hd__dfxtp_1
XTAP_TAPCELL_ROW_9_328 VGND VPWR sky130_fd_sc_hd__tapvpwrvgnd_1
Xhold553 lsu.load_fifo.queue\[4\]\[5\] VGND VGND VPWR VPWR net1021 sky130_fd_sc_hd__dlygate4sd3_1
X_3509_ net437 VGND VGND VPWR VPWR _0073_ sky130_fd_sc_hd__inv_2
Xhold597 lsu.load_fifo.queue\[1\]\[28\] VGND VGND VPWR VPWR net1065 sky130_fd_sc_hd__dlygate4sd3_1
Xhold586 lsu.load_fifo.queue\[6\]\[9\] VGND VGND VPWR VPWR net1054 sky130_fd_sc_hd__dlygate4sd3_1
X_4489_ clknet_leaf_77_clk _0546_ VGND VGND VPWR VPWR lsu.load_fifo.queue\[2\]\[1\]
+ sky130_fd_sc_hd__dfxtp_1
Xhold564 lsu.load_fifo.queue\[5\]\[5\] VGND VGND VPWR VPWR net1032 sky130_fd_sc_hd__dlygate4sd3_1
Xhold575 lsu.load_fifo.queue\[1\]\[30\] VGND VGND VPWR VPWR net1043 sky130_fd_sc_hd__dlygate4sd3_1
XFILLER_103_189 VGND VGND VPWR VPWR sky130_fd_sc_hd__fill_1
XFILLER_66_26 VGND VGND VPWR VPWR sky130_fd_sc_hd__fill_2
XFILLER_97_390 VGND VGND VPWR VPWR sky130_fd_sc_hd__fill_2
XFILLER_66_37 VPWR VGND VPWR VGND sky130_ef_sc_hd__decap_12
Xclkbuf_leaf_37_clk clknet_3_6__leaf_clk VGND VGND VPWR VPWR clknet_leaf_37_clk sky130_fd_sc_hd__clkbuf_8
XFILLER_45_449 VGND VGND VPWR VPWR sky130_fd_sc_hd__decap_4
XFILLER_25_173 VGND VGND VPWR VPWR sky130_fd_sc_hd__fill_1
XFILLER_15_63 VGND VGND VPWR VPWR sky130_fd_sc_hd__fill_1
XFILLER_95_305 VPWR VGND VPWR VGND sky130_ef_sc_hd__decap_12
XFILLER_0_261 VGND VGND VPWR VPWR sky130_fd_sc_hd__fill_1
XFILLER_95_349 VGND VGND VPWR VPWR sky130_fd_sc_hd__decap_4
Xclkbuf_leaf_28_clk clknet_3_3__leaf_clk VGND VGND VPWR VPWR clknet_leaf_28_clk sky130_fd_sc_hd__clkbuf_8
XTAP_TAPCELL_ROW_34_606 VGND VPWR sky130_fd_sc_hd__tapvpwrvgnd_1
XTAP_TAPCELL_ROW_62_915 VGND VPWR sky130_fd_sc_hd__tapvpwrvgnd_1
X_3860_ _1320_ _1319_ net360 VGND VGND VPWR VPWR _1321_ sky130_fd_sc_hd__mux2_1
X_2811_ net345 net1059 net226 VGND VGND VPWR VPWR _0324_ sky130_fd_sc_hd__mux2_1
X_3791_ lsu.load_fifo.queue\[0\]\[30\] lsu.load_fifo.queue\[1\]\[30\] lsu.load_fifo.queue\[2\]\[30\]
+ lsu.load_fifo.queue\[3\]\[30\] net395 net378 VGND VGND VPWR VPWR _1262_ sky130_fd_sc_hd__mux4_1
XFILLER_75_3 VGND VGND VPWR VPWR sky130_fd_sc_hd__fill_2
XTAP_TAPCELL_ROW_14_385 VGND VPWR sky130_fd_sc_hd__tapvpwrvgnd_1
X_2742_ net1080 net284 _2026_ VGND VGND VPWR VPWR _0262_ sky130_fd_sc_hd__mux2_1
XTAP_TAPCELL_ROW_42_694 VGND VPWR sky130_fd_sc_hd__tapvpwrvgnd_1
X_2673_ net541 net355 net233 VGND VGND VPWR VPWR _0197_ sky130_fd_sc_hd__mux2_1
X_4412_ clknet_leaf_82_clk _0469_ VGND VGND VPWR VPWR lsu.load_fifo.queue\[5\]\[20\]
+ sky130_fd_sc_hd__dfxtp_1
XPHY_EDGE_ROW_99_Right_99 VGND VGND VPWR VPWR sky130_fd_sc_hd__decap_3
XFILLER_98_121 VPWR VGND VPWR VGND sky130_ef_sc_hd__decap_12
X_4343_ clknet_leaf_79_clk _0400_ VGND VGND VPWR VPWR lsu.load_fifo.queue\[7\]\[17\]
+ sky130_fd_sc_hd__dfxtp_1
XFILLER_98_165 VGND VGND VPWR VPWR sky130_fd_sc_hd__decap_8
Xfanout307 lsu.load_fifo.data_in\[24\] VGND VGND VPWR VPWR net307 sky130_fd_sc_hd__dlymetal6s2s_1
Xfanout318 lsu.load_fifo.data_in\[18\] VGND VGND VPWR VPWR net318 sky130_fd_sc_hd__clkbuf_2
Xfanout329 lsu.load_fifo.data_in\[13\] VGND VGND VPWR VPWR net329 sky130_fd_sc_hd__buf_1
X_4274_ clknet_leaf_22_clk _0331_ VGND VGND VPWR VPWR lsu.load_fifo.queue\[9\]\[12\]
+ sky130_fd_sc_hd__dfxtp_1
X_3225_ net538 net275 _2050_ VGND VGND VPWR VPWR _0761_ sky130_fd_sc_hd__mux2_1
X_3156_ net780 net321 net178 VGND VGND VPWR VPWR _0658_ sky130_fd_sc_hd__mux2_1
XFILLER_36_18 VGND VGND VPWR VPWR sky130_fd_sc_hd__fill_1
X_2107_ lsu.load_counter\[12\] _1591_ VGND VGND VPWR VPWR _1597_ sky130_fd_sc_hd__nand2_1
X_3087_ net327 net1214 net185 VGND VGND VPWR VPWR _0591_ sky130_fd_sc_hd__mux2_1
XFILLER_36_29 VGND VGND VPWR VPWR sky130_fd_sc_hd__fill_2
Xclkbuf_leaf_19_clk clknet_3_2__leaf_clk VGND VGND VPWR VPWR clknet_leaf_19_clk sky130_fd_sc_hd__clkbuf_8
XFILLER_50_463 VPWR VGND VPWR VGND sky130_ef_sc_hd__decap_12
X_3989_ lsu.load_fifo.queue\[0\]\[1\] lsu.load_fifo.queue\[1\]\[1\] lsu.load_fifo.queue\[2\]\[1\]
+ lsu.load_fifo.queue\[3\]\[1\] net389 net372 VGND VGND VPWR VPWR _1431_ sky130_fd_sc_hd__mux4_1
XFILLER_6_309 VPWR VGND VPWR VGND sky130_ef_sc_hd__decap_12
Xhold361 lsu.load_fifo.queue\[7\]\[16\] VGND VGND VPWR VPWR net829 sky130_fd_sc_hd__dlygate4sd3_1
Xhold350 _0818_ VGND VGND VPWR VPWR net818 sky130_fd_sc_hd__dlygate4sd3_1
XFILLER_89_143 VPWR VGND VPWR VGND sky130_ef_sc_hd__decap_12
Xhold383 lsu.load_fifo.queue\[10\]\[3\] VGND VGND VPWR VPWR net851 sky130_fd_sc_hd__dlygate4sd3_1
Xhold372 lsu.load_fifo.queue\[6\]\[25\] VGND VGND VPWR VPWR net840 sky130_fd_sc_hd__dlygate4sd3_1
Xhold394 lsu.load_fifo.queue\[3\]\[12\] VGND VGND VPWR VPWR net862 sky130_fd_sc_hd__dlygate4sd3_1
XFILLER_104_487 VGND VGND VPWR VPWR sky130_fd_sc_hd__fill_1
XFILLER_77_47 VGND VGND VPWR VPWR sky130_fd_sc_hd__fill_1
XFILLER_93_57 VPWR VGND VPWR VGND sky130_ef_sc_hd__decap_12
XFILLER_33_408 VGND VGND VPWR VPWR sky130_fd_sc_hd__fill_2
XFILLER_60_205 VGND VGND VPWR VPWR sky130_fd_sc_hd__decap_3
XFILLER_41_474 VGND VGND VPWR VPWR sky130_fd_sc_hd__decap_6
XFILLER_9_147 VGND VGND VPWR VPWR sky130_fd_sc_hd__decap_4
XTAP_TAPCELL_ROW_11_355 VGND VPWR sky130_fd_sc_hd__tapvpwrvgnd_1
Xrebuffer6 net473 VGND VGND VPWR VPWR net474 sky130_fd_sc_hd__dlygate4sd1_1
XTAP_TAPCELL_ROW_97_1298 VGND VPWR sky130_fd_sc_hd__tapvpwrvgnd_1
XFILLER_5_375 VPWR VGND VPWR VGND sky130_ef_sc_hd__decap_12
XFILLER_96_625 VGND VGND VPWR VPWR sky130_fd_sc_hd__fill_1
XFILLER_95_113 VPWR VGND VPWR VGND sky130_ef_sc_hd__decap_12
XFILLER_68_338 VPWR VGND VPWR VGND sky130_ef_sc_hd__decap_12
XFILLER_3_55 VGND VGND VPWR VPWR sky130_fd_sc_hd__fill_1
XFILLER_76_360 VGND VGND VPWR VPWR sky130_fd_sc_hd__decap_4
X_3010_ net936 net349 net210 VGND VGND VPWR VPWR _0516_ sky130_fd_sc_hd__mux2_1
XFILLER_49_585 VGND VGND VPWR VPWR sky130_fd_sc_hd__decap_6
XTAP_TAPCELL_ROW_19_444 VGND VPWR sky130_fd_sc_hd__tapvpwrvgnd_1
XTAP_TAPCELL_ROW_47_742 VGND VPWR sky130_fd_sc_hd__tapvpwrvgnd_1
X_4961_ clknet_leaf_2_clk _1016_ _0147_ VGND VGND VPWR VPWR acc.byte1\[6\] sky130_fd_sc_hd__dfrtp_1
XTAP_TAPCELL_ROW_106_1394 VGND VPWR sky130_fd_sc_hd__tapvpwrvgnd_1
X_4892_ clknet_leaf_8_clk _0947_ VGND VGND VPWR VPWR lsu.load_fifo.queue\[12\]\[19\]
+ sky130_fd_sc_hd__dfxtp_1
X_3912_ lsu.load_fifo.queue\[4\]\[12\] lsu.load_fifo.queue\[5\]\[12\] lsu.load_fifo.queue\[6\]\[12\]
+ lsu.load_fifo.queue\[7\]\[12\] net391 net374 VGND VGND VPWR VPWR _1365_ sky130_fd_sc_hd__mux4_1
XFILLER_20_625 VGND VGND VPWR VPWR sky130_fd_sc_hd__decap_4
XFILLER_32_474 VGND VGND VPWR VPWR sky130_fd_sc_hd__fill_2
X_3843_ net1263 _1306_ net255 VGND VGND VPWR VPWR _1025_ sky130_fd_sc_hd__mux2_1
X_3774_ lsu.load_fifo.queue\[8\]\[31\] lsu.load_fifo.queue\[9\]\[31\] lsu.load_fifo.queue\[10\]\[31\]
+ lsu.load_fifo.queue\[11\]\[31\] net389 net372 VGND VGND VPWR VPWR _1246_ sky130_fd_sc_hd__mux4_1
X_2725_ net1097 net276 _2025_ VGND VGND VPWR VPWR _0246_ sky130_fd_sc_hd__mux2_1
XFILLER_105_207 VGND VGND VPWR VPWR sky130_fd_sc_hd__decap_6
Xclkbuf_leaf_8_clk clknet_3_1__leaf_clk VGND VGND VPWR VPWR clknet_leaf_8_clk sky130_fd_sc_hd__clkbuf_8
X_2656_ net279 net951 _2019_ VGND VGND VPWR VPWR _0183_ sky130_fd_sc_hd__mux2_1
X_2587_ lsu.current_load_addr\[6\] _1977_ net162 VGND VGND VPWR VPWR _0733_ sky130_fd_sc_hd__mux2_4
XTAP_TAPCELL_ROW_74_1040 VGND VPWR sky130_fd_sc_hd__tapvpwrvgnd_1
XFILLER_87_625 VGND VGND VPWR VPWR sky130_fd_sc_hd__fill_1
XFILLER_86_102 VPWR VGND VPWR VGND sky130_ef_sc_hd__decap_12
X_4326_ clknet_leaf_33_clk _0383_ VGND VGND VPWR VPWR lsu.load_fifo.queue\[7\]\[0\]
+ sky130_fd_sc_hd__dfxtp_1
X_4257_ clknet_leaf_58_clk _0314_ VGND VGND VPWR VPWR lsu.store_fifo.queue\[1\]\[5\]
+ sky130_fd_sc_hd__dfxtp_1
XFILLER_47_28 VGND VGND VPWR VPWR sky130_fd_sc_hd__fill_1
X_4188_ clknet_leaf_51_clk _0245_ VGND VGND VPWR VPWR lsu.store_fifo.queue\[8\]\[6\]
+ sky130_fd_sc_hd__dfxtp_1
X_3208_ net287 net882 _2049_ VGND VGND VPWR VPWR _0719_ sky130_fd_sc_hd__mux2_1
X_3139_ net681 net354 net180 VGND VGND VPWR VPWR _0641_ sky130_fd_sc_hd__mux2_1
XFILLER_55_522 VGND VGND VPWR VPWR sky130_fd_sc_hd__fill_1
XFILLER_82_363 VGND VGND VPWR VPWR sky130_fd_sc_hd__fill_1
XFILLER_70_525 VGND VGND VPWR VPWR sky130_fd_sc_hd__decap_6
XFILLER_27_279 VGND VGND VPWR VPWR sky130_fd_sc_hd__fill_1
XFILLER_7_629 VGND VGND VPWR VPWR sky130_fd_sc_hd__fill_1
XFILLER_5_3 VPWR VGND VPWR VGND sky130_ef_sc_hd__decap_12
Xhold180 lsu.store_fifo.queue\[11\]\[8\] VGND VGND VPWR VPWR net648 sky130_fd_sc_hd__dlygate4sd3_1
XFILLER_77_113 VGND VGND VPWR VPWR sky130_fd_sc_hd__fill_1
Xhold191 lsu.load_fifo.queue\[11\]\[3\] VGND VGND VPWR VPWR net659 sky130_fd_sc_hd__dlygate4sd3_1
XFILLER_77_135 VGND VGND VPWR VPWR sky130_fd_sc_hd__decap_4
XFILLER_73_330 VGND VGND VPWR VPWR sky130_fd_sc_hd__decap_6
XFILLER_37_72 VGND VGND VPWR VPWR sky130_fd_sc_hd__decap_4
XTAP_TAPCELL_ROW_16_403 VGND VPWR sky130_fd_sc_hd__tapvpwrvgnd_1
XTAP_TAPCELL_ROW_44_712 VGND VPWR sky130_fd_sc_hd__tapvpwrvgnd_1
XFILLER_61_558 VGND VGND VPWR VPWR sky130_fd_sc_hd__fill_2
XTAP_TAPCELL_ROW_99_1316 VGND VPWR sky130_fd_sc_hd__tapvpwrvgnd_1
XTAP_TAPCELL_ROW_24_491 VGND VPWR sky130_fd_sc_hd__tapvpwrvgnd_1
X_3490_ net431 VGND VGND VPWR VPWR _0054_ sky130_fd_sc_hd__inv_2
X_2510_ net395 net255 net381 VGND VGND VPWR VPWR _1918_ sky130_fd_sc_hd__a21oi_1
X_2441_ lsu.current_store_addr\[16\] _1871_ net241 VGND VGND VPWR VPWR _0805_ sky130_fd_sc_hd__mux2_1
X_2372_ lsu.store_counter\[2\] _1635_ VGND VGND VPWR VPWR _1811_ sky130_fd_sc_hd__and2_1
XFILLER_38_3 VGND VGND VPWR VPWR sky130_fd_sc_hd__decap_8
XFILLER_96_444 VGND VGND VPWR VPWR sky130_fd_sc_hd__decap_6
X_4111_ lsu.store_fifo.queue\[4\]\[0\] lsu.store_fifo.queue\[5\]\[0\] lsu.store_fifo.queue\[6\]\[0\]
+ lsu.store_fifo.queue\[7\]\[0\] net415 net409 VGND VGND VPWR VPWR _1542_ sky130_fd_sc_hd__mux4_1
XFILLER_96_477 VPWR VGND VPWR VGND sky130_ef_sc_hd__decap_12
X_4042_ net401 _1478_ VGND VGND VPWR VPWR _1479_ sky130_fd_sc_hd__nor2_1
XFILLER_49_371 VPWR VGND VPWR VGND sky130_ef_sc_hd__decap_12
XFILLER_49_393 VPWR VGND VPWR VGND sky130_ef_sc_hd__decap_12
XFILLER_91_193 VPWR VGND VPWR VGND sky130_ef_sc_hd__decap_12
X_4944_ clknet_leaf_64_clk _0999_ _0130_ VGND VGND VPWR VPWR net156 sky130_fd_sc_hd__dfrtp_1
X_4875_ clknet_leaf_20_clk _0930_ VGND VGND VPWR VPWR lsu.load_fifo.queue\[12\]\[2\]
+ sky130_fd_sc_hd__dfxtp_1
X_3826_ lsu.load_fifo.queue\[8\]\[25\] lsu.load_fifo.queue\[9\]\[25\] lsu.load_fifo.queue\[10\]\[25\]
+ lsu.load_fifo.queue\[11\]\[25\] net390 net373 VGND VGND VPWR VPWR _1292_ sky130_fd_sc_hd__mux4_1
XFILLER_20_488 VGND VGND VPWR VPWR sky130_fd_sc_hd__decap_4
X_3757_ _1125_ _1229_ _1235_ VGND VGND VPWR VPWR _1236_ sky130_fd_sc_hd__and3_1
XFILLER_106_505 VGND VGND VPWR VPWR sky130_fd_sc_hd__fill_2
X_2708_ net287 net943 _2023_ VGND VGND VPWR VPWR _0231_ sky130_fd_sc_hd__mux2_1
X_3688_ _1164_ _1169_ VGND VGND VPWR VPWR _1170_ sky130_fd_sc_hd__nand2_1
X_2639_ _2013_ _2014_ VGND VGND VPWR VPWR _2015_ sky130_fd_sc_hd__or2_1
XFILLER_101_232 VGND VGND VPWR VPWR sky130_fd_sc_hd__fill_2
XFILLER_99_293 VPWR VGND VPWR VGND sky130_ef_sc_hd__decap_12
XFILLER_87_433 VPWR VGND VPWR VGND sky130_ef_sc_hd__decap_12
X_4309_ clknet_leaf_10_clk _0366_ VGND VGND VPWR VPWR lsu.load_fifo.queue\[10\]\[15\]
+ sky130_fd_sc_hd__dfxtp_1
XFILLER_59_113 VGND VGND VPWR VPWR sky130_fd_sc_hd__fill_1
XFILLER_28_533 VGND VGND VPWR VPWR sky130_fd_sc_hd__fill_2
XFILLER_43_503 VGND VGND VPWR VPWR sky130_fd_sc_hd__fill_1
XTAP_TAPCELL_ROW_83_1139 VGND VPWR sky130_fd_sc_hd__tapvpwrvgnd_1
XFILLER_15_249 VGND VGND VPWR VPWR sky130_fd_sc_hd__decap_3
XFILLER_7_437 VGND VGND VPWR VPWR sky130_fd_sc_hd__decap_8
XTAP_TAPCELL_ROW_21_461 VGND VPWR sky130_fd_sc_hd__tapvpwrvgnd_1
XTAP_TAPCELL_ROW_94_1268 VGND VPWR sky130_fd_sc_hd__tapvpwrvgnd_1
XFILLER_2_175 VGND VGND VPWR VPWR sky130_fd_sc_hd__decap_4
XFILLER_93_447 VGND VGND VPWR VPWR sky130_fd_sc_hd__fill_1
XFILLER_19_555 VGND VGND VPWR VPWR sky130_fd_sc_hd__decap_4
XFILLER_46_330 VGND VGND VPWR VPWR sky130_fd_sc_hd__decap_4
XFILLER_80_108 VGND VGND VPWR VPWR sky130_fd_sc_hd__fill_1
XTAP_TAPCELL_ROW_29_550 VGND VPWR sky130_fd_sc_hd__tapvpwrvgnd_1
XPHY_EDGE_ROW_14_Left_121 VGND VGND VPWR VPWR sky130_fd_sc_hd__decap_3
XFILLER_64_81 VGND VGND VPWR VPWR sky130_fd_sc_hd__decap_3
X_2990_ net605 net320 net189 VGND VGND VPWR VPWR _0498_ sky130_fd_sc_hd__mux2_1
XTAP_TAPCELL_ROW_103_1364 VGND VPWR sky130_fd_sc_hd__tapvpwrvgnd_1
XFILLER_61_388 VGND VGND VPWR VPWR sky130_fd_sc_hd__decap_4
X_4660_ clknet_leaf_49_clk _0717_ VGND VGND VPWR VPWR lsu.store_fifo.queue\[15\]\[0\]
+ sky130_fd_sc_hd__dfxtp_1
X_3611_ net435 VGND VGND VPWR VPWR _0175_ sky130_fd_sc_hd__inv_2
X_4591_ clknet_leaf_32_clk _0648_ VGND VGND VPWR VPWR lsu.load_fifo.queue\[8\]\[7\]
+ sky130_fd_sc_hd__dfxtp_1
X_3542_ net438 VGND VGND VPWR VPWR _0106_ sky130_fd_sc_hd__inv_2
XPHY_EDGE_ROW_23_Left_130 VGND VGND VPWR VPWR sky130_fd_sc_hd__decap_3
X_3473_ net437 VGND VGND VPWR VPWR _0037_ sky130_fd_sc_hd__inv_2
X_2424_ lsu.current_store_addr\[19\] _1855_ lsu.current_store_addr\[20\] VGND VGND
+ VPWR VPWR _1859_ sky130_fd_sc_hd__a21oi_1
XTAP_TAPCELL_ROW_71_1010 VGND VPWR sky130_fd_sc_hd__tapvpwrvgnd_1
X_2355_ lsu.store_counter\[12\] _1591_ VGND VGND VPWR VPWR _1794_ sky130_fd_sc_hd__nand2_1
XFILLER_69_433 VPWR VGND VPWR VGND sky130_ef_sc_hd__decap_12
X_2286_ _1743_ _1745_ VGND VGND VPWR VPWR _0897_ sky130_fd_sc_hd__and2_1
XFILLER_49_190 VGND VGND VPWR VPWR sky130_fd_sc_hd__decap_3
X_4025_ net271 _1463_ VGND VGND VPWR VPWR _1464_ sky130_fd_sc_hd__nor2_1
XFILLER_25_525 VPWR VGND VPWR VGND sky130_ef_sc_hd__decap_12
XFILLER_25_558 VGND VGND VPWR VPWR sky130_fd_sc_hd__fill_2
XFILLER_64_193 VGND VGND VPWR VPWR sky130_fd_sc_hd__decap_3
X_4927_ clknet_leaf_72_clk _0982_ VGND VGND VPWR VPWR lsu.load_fifo.queue\[13\]\[22\]
+ sky130_fd_sc_hd__dfxtp_1
X_4858_ clknet_leaf_40_clk _0913_ _0108_ VGND VGND VPWR VPWR lsu.load_counter\[8\]
+ sky130_fd_sc_hd__dfrtp_2
X_3809_ lsu.load_fifo.queue\[12\]\[27\] lsu.load_fifo.queue\[13\]\[27\] lsu.load_fifo.queue\[14\]\[27\]
+ lsu.load_fifo.queue\[15\]\[27\] net387 net373 VGND VGND VPWR VPWR _1277_ sky130_fd_sc_hd__mux4_1
X_4789_ clknet_leaf_70_clk _0846_ VGND VGND VPWR VPWR lsu.store_fifo.queue\[0\]\[9\]
+ sky130_fd_sc_hd__dfxtp_1
XFILLER_0_613 VGND VGND VPWR VPWR sky130_fd_sc_hd__decap_3
XFILLER_102_585 VGND VGND VPWR VPWR sky130_fd_sc_hd__decap_3
XFILLER_85_47 VGND VGND VPWR VPWR sky130_fd_sc_hd__fill_1
XFILLER_75_447 VGND VGND VPWR VPWR sky130_fd_sc_hd__fill_1
XFILLER_16_525 VGND VGND VPWR VPWR sky130_fd_sc_hd__decap_6
XTAP_TAPCELL_ROW_26_520 VGND VPWR sky130_fd_sc_hd__tapvpwrvgnd_1
XFILLER_43_322 VGND VGND VPWR VPWR sky130_fd_sc_hd__fill_1
XFILLER_16_569 VPWR VGND VPWR VGND sky130_ef_sc_hd__decap_12
XFILLER_34_62 VGND VGND VPWR VPWR sky130_fd_sc_hd__decap_3
XFILLER_34_73 VGND VGND VPWR VPWR sky130_fd_sc_hd__fill_2
XFILLER_7_223 VGND VGND VPWR VPWR sky130_fd_sc_hd__fill_1
XFILLER_7_245 VGND VGND VPWR VPWR sky130_fd_sc_hd__fill_2
XFILLER_98_506 VGND VGND VPWR VPWR sky130_fd_sc_hd__decap_3
XFILLER_3_473 VPWR VGND VPWR VGND sky130_ef_sc_hd__decap_12
X_2140_ _1625_ _1626_ VGND VGND VPWR VPWR _1630_ sky130_fd_sc_hd__nor2_1
X_2071_ net4 net3 _1558_ net23 VGND VGND VPWR VPWR _1561_ sky130_fd_sc_hd__or4_4
XFILLER_81_439 VGND VGND VPWR VPWR sky130_fd_sc_hd__decap_4
XFILLER_46_193 VGND VGND VPWR VPWR sky130_fd_sc_hd__decap_3
X_2973_ net647 net354 net192 VGND VGND VPWR VPWR _0481_ sky130_fd_sc_hd__mux2_1
XFILLER_61_185 VGND VGND VPWR VPWR sky130_fd_sc_hd__fill_2
X_4712_ clknet_leaf_28_clk net855 VGND VGND VPWR VPWR net119 sky130_fd_sc_hd__dfxtp_1
XTAP_TAPCELL_ROW_32_578 VGND VPWR sky130_fd_sc_hd__tapvpwrvgnd_1
XTAP_TAPCELL_ROW_60_887 VGND VPWR sky130_fd_sc_hd__tapvpwrvgnd_1
X_4643_ clknet_leaf_79_clk _0700_ VGND VGND VPWR VPWR lsu.load_fifo.queue\[15\]\[27\]
+ sky130_fd_sc_hd__dfxtp_1
Xhold702 net131 VGND VGND VPWR VPWR net1170 sky130_fd_sc_hd__dlygate4sd3_1
X_4574_ clknet_leaf_71_clk _0631_ VGND VGND VPWR VPWR lsu.load_fifo.queue\[0\]\[22\]
+ sky130_fd_sc_hd__dfxtp_1
Xmax_cap421 _1553_ VGND VGND VPWR VPWR net421 sky130_fd_sc_hd__buf_1
X_3525_ net440 VGND VGND VPWR VPWR _0089_ sky130_fd_sc_hd__inv_2
Xhold746 lsu.load_fifo.queue\[1\]\[14\] VGND VGND VPWR VPWR net1214 sky130_fd_sc_hd__dlygate4sd3_1
Xhold724 lsu.load_fifo.queue\[1\]\[18\] VGND VGND VPWR VPWR net1192 sky130_fd_sc_hd__dlygate4sd3_1
Xhold735 lsu.store_fifo.queue\[3\]\[2\] VGND VGND VPWR VPWR net1203 sky130_fd_sc_hd__dlygate4sd3_1
Xhold713 lsu.store_fifo.queue\[1\]\[8\] VGND VGND VPWR VPWR net1181 sky130_fd_sc_hd__dlygate4sd3_1
XFILLER_89_517 VGND VGND VPWR VPWR sky130_fd_sc_hd__decap_4
Xhold757 lsu.store_fifo.queue\[3\]\[9\] VGND VGND VPWR VPWR net1225 sky130_fd_sc_hd__dlygate4sd3_1
Xhold779 net152 VGND VGND VPWR VPWR net1247 sky130_fd_sc_hd__dlygate4sd3_1
Xhold768 lsu.store_fifo.queue\[7\]\[7\] VGND VGND VPWR VPWR net1236 sky130_fd_sc_hd__dlygate4sd3_1
X_3456_ net428 VGND VGND VPWR VPWR _0020_ sky130_fd_sc_hd__inv_2
X_2407_ _1842_ VGND VGND VPWR VPWR _1843_ sky130_fd_sc_hd__inv_2
X_3387_ net1086 net348 net198 VGND VGND VPWR VPWR _1037_ sky130_fd_sc_hd__mux2_1
X_2338_ lsu.loader_state\[1\] _1117_ _1777_ VGND VGND VPWR VPWR _1778_ sky130_fd_sc_hd__or3_1
X_2269_ lsu.store_counter\[19\] lsu.store_counter\[18\] _1733_ VGND VGND VPWR VPWR
+ _1734_ sky130_fd_sc_hd__nand3_1
XTAP_TAPCELL_ROW_68_976 VGND VPWR sky130_fd_sc_hd__tapvpwrvgnd_1
X_4008_ lsu.store_fifo.queue\[0\]\[9\] lsu.store_fifo.queue\[1\]\[9\] lsu.store_fifo.queue\[2\]\[9\]
+ lsu.store_fifo.queue\[3\]\[9\] net411 net406 VGND VGND VPWR VPWR _1448_ sky130_fd_sc_hd__mux4_1
XFILLER_13_517 VPWR VGND VPWR VGND sky130_ef_sc_hd__decap_12
XTAP_TAPCELL_ROW_80_1109 VGND VPWR sky130_fd_sc_hd__tapvpwrvgnd_1
XFILLER_106_121 VGND VGND VPWR VPWR sky130_fd_sc_hd__fill_1
XTAP_TAPCELL_ROW_91_1227 VGND VPWR sky130_fd_sc_hd__tapvpwrvgnd_1
XFILLER_0_421 VPWR VGND VPWR VGND sky130_ef_sc_hd__decap_12
Xhold40 lsu.store_fifo.queue\[14\]\[9\] VGND VGND VPWR VPWR net508 sky130_fd_sc_hd__dlygate4sd3_1
Xhold73 lsu.load_fifo.queue\[11\]\[0\] VGND VGND VPWR VPWR net541 sky130_fd_sc_hd__dlygate4sd3_1
XFILLER_75_222 VGND VGND VPWR VPWR sky130_fd_sc_hd__fill_2
Xhold51 lsu.store_fifo.queue\[8\]\[3\] VGND VGND VPWR VPWR net519 sky130_fd_sc_hd__dlygate4sd3_1
Xhold62 lsu.load_fifo.queue\[2\]\[8\] VGND VGND VPWR VPWR net530 sky130_fd_sc_hd__dlygate4sd3_1
Xhold95 net122 VGND VGND VPWR VPWR net563 sky130_fd_sc_hd__dlygate4sd3_1
Xhold84 lsu.load_fifo.queue\[2\]\[10\] VGND VGND VPWR VPWR net552 sky130_fd_sc_hd__dlygate4sd3_1
XFILLER_16_300 VGND VGND VPWR VPWR sky130_fd_sc_hd__decap_8
XFILLER_71_461 VPWR VGND VPWR VGND sky130_ef_sc_hd__decap_12
XTAP_TAPCELL_ROW_100_1334 VGND VPWR sky130_fd_sc_hd__tapvpwrvgnd_1
XFILLER_77_7 VGND VGND VPWR VPWR sky130_fd_sc_hd__fill_1
XFILLER_8_587 VGND VGND VPWR VPWR sky130_fd_sc_hd__fill_1
XANTENNA_4 lsu.current_load_addr\[5\] VGND VGND VPWR VPWR sky130_fd_sc_hd__diode_2
XFILLER_6_66 VGND VGND VPWR VPWR sky130_fd_sc_hd__fill_1
X_3310_ net305 net64 net249 VGND VGND VPWR VPWR _0872_ sky130_fd_sc_hd__mux2_1
XFILLER_3_281 VGND VGND VPWR VPWR sky130_fd_sc_hd__fill_2
X_4290_ clknet_leaf_13_clk _0347_ VGND VGND VPWR VPWR lsu.load_fifo.queue\[9\]\[28\]
+ sky130_fd_sc_hd__dfxtp_1
X_3241_ net549 lsu.current_load_addr\[13\] net237 VGND VGND VPWR VPWR _0779_ sky130_fd_sc_hd__mux2_1
XFILLER_79_561 VGND VGND VPWR VPWR sky130_fd_sc_hd__decap_4
X_3172_ net934 net354 net205 VGND VGND VPWR VPWR _0673_ sky130_fd_sc_hd__mux2_1
XFILLER_20_3 VGND VGND VPWR VPWR sky130_fd_sc_hd__decap_6
XFILLER_39_425 VGND VGND VPWR VPWR sky130_fd_sc_hd__decap_4
X_2123_ lsu.load_counter\[9\] _1609_ _1612_ lsu.load_counter\[8\] VGND VGND VPWR VPWR
+ _1613_ sky130_fd_sc_hd__o22ai_2
XFILLER_94_531 VGND VGND VPWR VPWR sky130_fd_sc_hd__fill_1
XFILLER_94_597 VGND VGND VPWR VPWR sky130_fd_sc_hd__decap_8
XTAP_TAPCELL_ROW_37_637 VGND VPWR sky130_fd_sc_hd__tapvpwrvgnd_1
XFILLER_47_480 VGND VGND VPWR VPWR sky130_fd_sc_hd__decap_3
XTAP_TAPCELL_ROW_65_946 VGND VPWR sky130_fd_sc_hd__tapvpwrvgnd_1
XFILLER_34_141 VGND VGND VPWR VPWR sky130_fd_sc_hd__decap_4
XFILLER_62_450 VGND VGND VPWR VPWR sky130_fd_sc_hd__fill_1
XFILLER_62_472 VGND VGND VPWR VPWR sky130_fd_sc_hd__decap_4
XFILLER_22_347 VGND VGND VPWR VPWR sky130_fd_sc_hd__fill_1
X_2956_ net318 net986 net214 VGND VGND VPWR VPWR _0467_ sky130_fd_sc_hd__mux2_1
X_2887_ net764 net324 net196 VGND VGND VPWR VPWR _0398_ sky130_fd_sc_hd__mux2_1
X_4626_ clknet_leaf_24_clk _0683_ VGND VGND VPWR VPWR lsu.load_fifo.queue\[15\]\[10\]
+ sky130_fd_sc_hd__dfxtp_1
Xhold510 lsu.store_fifo.queue\[7\]\[5\] VGND VGND VPWR VPWR net978 sky130_fd_sc_hd__dlygate4sd3_1
Xhold532 lsu.load_fifo.queue\[13\]\[21\] VGND VGND VPWR VPWR net1000 sky130_fd_sc_hd__dlygate4sd3_1
XTAP_TAPCELL_ROW_77_1082 VGND VPWR sky130_fd_sc_hd__tapvpwrvgnd_1
XTAP_TAPCELL_ROW_9_329 VGND VPWR sky130_fd_sc_hd__tapvpwrvgnd_1
Xhold521 lsu.load_fifo.queue\[4\]\[3\] VGND VGND VPWR VPWR net989 sky130_fd_sc_hd__dlygate4sd3_1
Xhold554 lsu.store_fifo.queue\[6\]\[7\] VGND VGND VPWR VPWR net1022 sky130_fd_sc_hd__dlygate4sd3_1
X_4557_ clknet_leaf_6_clk _0614_ VGND VGND VPWR VPWR lsu.load_fifo.queue\[0\]\[5\]
+ sky130_fd_sc_hd__dfxtp_1
Xhold543 lsu.store_fifo.queue\[5\]\[2\] VGND VGND VPWR VPWR net1011 sky130_fd_sc_hd__dlygate4sd3_1
XFILLER_104_625 VGND VGND VPWR VPWR sky130_fd_sc_hd__fill_2
XFILLER_103_113 VGND VGND VPWR VPWR sky130_fd_sc_hd__fill_2
Xhold576 lsu.load_fifo.queue\[1\]\[2\] VGND VGND VPWR VPWR net1044 sky130_fd_sc_hd__dlygate4sd3_1
X_3508_ net430 VGND VGND VPWR VPWR _0072_ sky130_fd_sc_hd__inv_2
X_4488_ clknet_leaf_35_clk _0545_ VGND VGND VPWR VPWR lsu.load_fifo.queue\[2\]\[0\]
+ sky130_fd_sc_hd__dfxtp_1
Xhold565 lsu.load_fifo.queue\[10\]\[31\] VGND VGND VPWR VPWR net1033 sky130_fd_sc_hd__dlygate4sd3_1
Xhold587 lsu.load_fifo.queue\[1\]\[4\] VGND VGND VPWR VPWR net1055 sky130_fd_sc_hd__dlygate4sd3_1
X_3439_ net437 VGND VGND VPWR VPWR _0003_ sky130_fd_sc_hd__inv_2
Xhold598 lsu.load_fifo.queue\[10\]\[15\] VGND VGND VPWR VPWR net1066 sky130_fd_sc_hd__dlygate4sd3_1
XFILLER_106_89 VGND VGND VPWR VPWR sky130_fd_sc_hd__fill_1
XFILLER_66_49 VGND VGND VPWR VPWR sky130_fd_sc_hd__decap_4
XFILLER_17_119 VGND VGND VPWR VPWR sky130_fd_sc_hd__fill_1
XFILLER_38_491 VGND VGND VPWR VPWR sky130_fd_sc_hd__fill_1
XFILLER_82_15 VPWR VGND VPWR VGND sky130_ef_sc_hd__decap_12
XFILLER_40_133 VGND VGND VPWR VPWR sky130_fd_sc_hd__fill_1
XFILLER_40_144 VGND VGND VPWR VPWR sky130_fd_sc_hd__decap_8
XFILLER_31_52 VGND VGND VPWR VPWR sky130_fd_sc_hd__decap_4
XFILLER_95_317 VPWR VGND VPWR VGND sky130_ef_sc_hd__decap_12
XFILLER_0_273 VGND VGND VPWR VPWR sky130_fd_sc_hd__decap_3
XFILLER_0_251 VGND VGND VPWR VPWR sky130_fd_sc_hd__fill_1
XFILLER_76_520 VGND VGND VPWR VPWR sky130_fd_sc_hd__decap_8
XFILLER_48_222 VGND VGND VPWR VPWR sky130_fd_sc_hd__decap_4
XFILLER_63_225 VGND VGND VPWR VPWR sky130_fd_sc_hd__decap_4
XFILLER_91_556 VGND VGND VPWR VPWR sky130_fd_sc_hd__decap_4
XTAP_TAPCELL_ROW_34_607 VGND VPWR sky130_fd_sc_hd__tapvpwrvgnd_1
XTAP_TAPCELL_ROW_62_916 VGND VPWR sky130_fd_sc_hd__tapvpwrvgnd_1
XFILLER_91_589 VGND VGND VPWR VPWR sky130_fd_sc_hd__fill_2
XFILLER_72_81 VGND VGND VPWR VPWR sky130_fd_sc_hd__decap_3
XFILLER_31_177 VGND VGND VPWR VPWR sky130_fd_sc_hd__decap_6
X_2810_ net347 net970 net228 VGND VGND VPWR VPWR _0323_ sky130_fd_sc_hd__mux2_1
X_3790_ lsu.load_fifo.queue\[4\]\[30\] lsu.load_fifo.queue\[5\]\[30\] lsu.load_fifo.queue\[6\]\[30\]
+ lsu.load_fifo.queue\[7\]\[30\] net395 net378 VGND VGND VPWR VPWR _1261_ sky130_fd_sc_hd__mux4_1
XTAP_TAPCELL_ROW_14_386 VGND VPWR sky130_fd_sc_hd__tapvpwrvgnd_1
X_2741_ net1030 net286 _2026_ VGND VGND VPWR VPWR _0261_ sky130_fd_sc_hd__mux2_1
XTAP_TAPCELL_ROW_42_695 VGND VPWR sky130_fd_sc_hd__tapvpwrvgnd_1
X_2672_ net418 _1998_ net417 VGND VGND VPWR VPWR _2022_ sky130_fd_sc_hd__and3b_2
XFILLER_68_3 VGND VGND VPWR VPWR sky130_fd_sc_hd__decap_3
X_4411_ clknet_leaf_9_clk _0468_ VGND VGND VPWR VPWR lsu.load_fifo.queue\[5\]\[19\]
+ sky130_fd_sc_hd__dfxtp_1
X_4342_ clknet_leaf_31_clk _0399_ VGND VGND VPWR VPWR lsu.load_fifo.queue\[7\]\[16\]
+ sky130_fd_sc_hd__dfxtp_1
XFILLER_98_133 VGND VGND VPWR VPWR sky130_fd_sc_hd__fill_2
Xfanout308 net309 VGND VGND VPWR VPWR net308 sky130_fd_sc_hd__clkbuf_2
X_4273_ clknet_leaf_84_clk _0330_ VGND VGND VPWR VPWR lsu.load_fifo.queue\[9\]\[11\]
+ sky130_fd_sc_hd__dfxtp_1
Xfanout319 lsu.load_fifo.data_in\[18\] VGND VGND VPWR VPWR net319 sky130_fd_sc_hd__buf_1
XFILLER_100_116 VGND VGND VPWR VPWR sky130_fd_sc_hd__decap_4
XFILLER_86_306 VGND VGND VPWR VPWR sky130_fd_sc_hd__fill_2
X_3224_ net646 net276 _2050_ VGND VGND VPWR VPWR _0760_ sky130_fd_sc_hd__mux2_1
.ends
